// LTRA lossy transmission line (ngspice O card): recursive convolution of the
// h1'/h2/h3' impulse responses over the accepted transient history.
// Exact small-signal dispersion is supplied by models/ltra_ac.zig through
// the device's frequency hook; the static rows below remain the DC limit.
//
// Verilog-A implementation: Omar El-Sawy, University of Waterloo.
// Based on: ngspice LTRA (ltra/ltraload.c, ltramisc.c, ltratemp.c,
//   ltraacct.c) -- Roychowdhury & Pederson, "Efficient transient simulation
//   of lossy interconnect", DAC'91. Bessel fits from Numerical Recipes.
//   ngspice: Copyright Regents of the University of California and others,
//   modified BSD license.
// Transcribed from ngspice's numbers through the retired native device
// (ltra_native.zig): ngspice-compatible where the
// reference cuts corners (the h2 interval mismatch at i == auxindex, the
// duplicated straight-line check in the maxSafeStep bisection). On the LTRA
// decks it reproduces that device to 1e-12 relative.
//
// erfc is an analog function below (not a VAMS builtin), within 1.9e-13 of
// libm, so the RC kernels are not bit-equal to ngspice's.
//
// ponytail: fixed history of cap = 8192 points with ngspice's straight-line
// compaction past it, then dead-front or least-bent drops that keep the
// delay window sampled (ngspice grows its history instead). Growable
// per-instance storage would lift the ceiling; VerA has none.
//
// State model: every variable a later evaluation reads is held (§5.10): an
// evaluation starts from what the last ACCEPTED one left, so the history
// append at the end of the block persists only for accepted points. The
// static solve a transient starts from seeds the history (analysis("tran")
// covers it, §4.6.1), as the native t = 0 commit did.
//
// Card keyword `abs` is a reserved word (LRM §4.3), so it is `brkabs` here and
// needs a host alias, as in models/lossy_tline.va.

`include "constants.vams"
`include "disciplines.vams"

module ltra(p1, n1, p2, n2);
    inout p1, n1, p2, n2;
    electrical p1, n1, p2, n2;
    branch (p1, n1) br1;   // I(br1): current into the line at port 1
    branch (p2, n2) br2;

    // .model ltra card (ngspice ltra.c IOP table).
    parameter real r   = 0.0 from [0:inf);
    parameter real l   = 0.0 from [0:inf);
    parameter real g   = 0.0 from [0:inf);
    parameter real c   = 0.0 from [0:inf);
    parameter real len = 0.0 from [0:inf);
    parameter real compactrel = 1e-3  from [0:inf);   // straight-line reltol
    parameter real compactabs = 1e-12 from [0:inf);   // straight-line abstol
    parameter real chopreltol = 0.0   from [0:inf);   // 0 = never truncate
    parameter integer steplimit    = 1 from [0:1];    // dt <= td
    parameter integer truncdontcut = 0 from [0:1];    // skip maxSafeStep
    parameter real rel    = 1.0 from (0:inf);         // wavefront test, ngspice REL
    parameter real brkabs = 1.0 from (0:inf);         // wavefront test, ngspice ABS

    localparam integer cap = 8192;        // history capacity (native CAP)
    localparam integer nbrk = 8;          // pending wavefront breakpoints
    localparam real pi = 3.14159265358979323846;
    // LTRAspecialCase §1.1; RG/rejects are routed to lossy_tline.va.
    localparam integer wave = (l > 0.0) && (c > 0.0) && (g == 0.0);
    localparam integer rlc  = wave && (r > 0.0);
    localparam integer rcase = !wave;

    // ---- Bessel fits in exponentially scaled form, e^-x * I(x), x >= 0 ----
    analog function real bessi0e;
        input x;
        real x, y;
        begin
            if (x < 3.75) begin
                y = x / 3.75;
                y = y * y;
                bessi0e = exp(-x) * (1.0 + y * (3.5156229 + y * (3.0899424 + y * (1.2067492
                    + y * (0.2659732 + y * (0.360768e-1 + y * 0.45813e-2))))));
            end else begin
                y = 3.75 / x;
                bessi0e = (1.0 / sqrt(x)) * (0.39894228 + y * (0.1328592e-1
                    + y * (0.225319e-2 + y * (-0.157565e-2 + y * (0.916281e-2
                    + y * (-0.2057706e-1 + y * (0.2635537e-1 + y * (-0.1647633e-1
                    + y * 0.392377e-2))))))));
            end
        end
    endfunction

    // Large-x tail shared by I1 and I1/x.
    analog function real bessi1tail;
        input y;
        real y, a;
        begin
            a = 0.2282967e-1 + y * (-0.2895312e-1 + y * (0.1787654e-1 - y * 0.420059e-2));
            bessi1tail = 0.39894228 + y * (-0.3988024e-1 + y * (-0.362018e-2
                + y * (0.163801e-2 + y * (-0.1031555e-1 + y * a))));
        end
    endfunction

    analog function real bessi1e;
        input x;
        real x, y;
        begin
            if (x < 3.75) begin
                y = x / 3.75;
                y = y * y;
                bessi1e = exp(-x) * x * (0.5 + y * (0.87890594 + y * (0.51498869 + y * (0.15084934
                    + y * (0.2658733e-1 + y * (0.301532e-2 + y * 0.32411e-3))))));
            end else
                bessi1e = bessi1tail(3.75 / x) / sqrt(x);
        end
    endfunction

    // e^-x * I1(x)/x, finite at x = 0.
    analog function real bessi1xoverxe;
        input x;
        real x, y;
        begin
            if (x < 3.75) begin
                y = x / 3.75;
                y = y * y;
                bessi1xoverxe = exp(-x) * (0.5 + y * (0.87890594 + y * (0.51498869 + y * (0.15084934
                    + y * (0.2658733e-1 + y * (0.301532e-2 + y * 0.32411e-3))))));
            end else
                bessi1xoverxe = bessi1tail(3.75 / x) / (x * sqrt(x));
        end
    endfunction

    // ---- §1.4 kernels (ltramisc.c); G = 0, so alpha = beta ----
    // h2(t) = alpha^2 T e^{-beta t} I1(x)/x, x = alpha sqrt(t^2 - T^2).
    analog function real rlch2;
        input t, tt, alpha, beta;
        real t, tt, alpha, beta, barg;
        begin
            if (alpha == 0.0 || t < tt)
                rlch2 = 0.0;
            else begin
                barg = (t != tt) ? alpha * sqrt(t * t - tt * tt) : 0.0;
                rlch2 = alpha * alpha * tt * exp(barg - beta * t) * bessi1xoverxe(barg);
            end
        end
    endfunction

    // Twice-integrated h1': t e^{-beta t}[I0(beta t) + I1(beta t)] - t.
    analog function real rlch1dash2;
        input t, beta;
        real t, beta;
        begin
            if (beta == 0.0)
                rlch1dash2 = t;
            else if (beta * t == 0.0)
                rlch1dash2 = 0.0;
            else
                rlch1dash2 = (bessi1e(beta * t) + bessi0e(beta * t)) * t - t;
        end
    endfunction

    analog function real rch1dash2;
        input t, cbyr;
        real t, cbyr;
        rch1dash2 = sqrt(4.0 * cbyr * t / pi);
    endfunction

    // erfc is not a VAMS-2023 builtin (Tables 4-14, 4-15): VerA's
    // tests/conformance/tests/netlist/erfc.vh, series below |x| = 1.5, continued fraction
    // above. Within 1.9e-13 relative of libm erfc on [-6, 6], not bit-equal.
    analog function real erfc;
        input x;
        real x, a, s, term, f;
        integer n;
        begin
            a = (x < 0.0) ? -x : x;
            if (a < 1.5) begin
                term = a;
                s = a;
                for (n = 1; n < 60; n = n + 1) begin
                    term = term * 2.0 * a * a / (2 * n + 1);
                    s = s + term;
                end
                erfc = 1.0 - 1.12837916709551257390 * exp(-a * a) * s;
            end else begin
                f = a;
                for (n = 60; n > 0; n = n - 1)
                    f = a + (n / 2.0) / f;
                erfc = 0.5 * 1.12837916709551257390 * exp(-a * a) / f;
            end
            if (x < 0.0)
                erfc = 2.0 - erfc;
        end
    endfunction

    analog function real rch2int2;
        input t, rclsqr;
        real t, rclsqr, a;
        begin
            if (t == 0.0)
                rch2int2 = 0.0;
            else begin
                a = rclsqr / (4.0 * t);
                rch2int2 = (t + rclsqr * 0.5) * erfc(sqrt(a))
                    - sqrt(t * rclsqr / pi) * exp(-a);
            end
        end
    endfunction

    analog function real rch3dash2;
        input t, cbyr, rclsqr;
        real t, cbyr, rclsqr, a;
        begin
            if (t == 0.0)
                rch3dash2 = 0.0;
            else begin
                a = rclsqr / (4.0 * t);
                rch3dash2 = sqrt(cbyr) * (2.0 * sqrt(t / pi) * exp(-a)
                    - sqrt(rclsqr) * erfc(sqrt(a)));
            end
        end
    endfunction

    // ---- §1.5 piecewise-linear segment integrals (ltramisc.c) ----
    analog function real intlin;
        input lo, hi, lov, hiv, t1, t2;
        real lo, hi, lov, hiv, t1, t2, m;
        begin
            if (t2 - t1 == 0.0)
                intlin = 0.0;
            else begin
                m = (hiv - lov) / (t2 - t1);
                intlin = (hi - lo) * lov + 0.5 * m * ((hi - t1) * (hi - t1) - (lo - t1) * (lo - t1));
            end
        end
    endfunction

    analog function real twiceintlin;
        input lo, hi, olo, lov, hiv, t1, t2;
        real lo, hi, olo, lov, hiv, t1, t2, m, a1, a2, a3, s;
        begin
            if (t2 - t1 == 0.0)
                twiceintlin = 0.0;
            else begin
                m = (hiv - lov) / (t2 - t1);
                a1 = hi - t1;
                a2 = lo - t1;
                a3 = olo - t1;
                s = lov * ((hi - olo) * (hi - olo) - (lo - olo) * (lo - olo));
                s = s + m * ((a1 * a1 * a1 - a2 * a2 * a2) / 3.0 - a3 * a3 * (hi - lo));
                twiceintlin = s * 0.5;
            end
        end
    endfunction

    // Triangle-vs-quadrilateral collinearity test (LTRAstraightLineCheck),
    // as a ratio: below 1 is straight.
    analog function real bend;
        input x1, y1, x2, y2, x3, y3, rtol, atol;
        real x1, y1, x2, y2, x3, y3, rtol, atol, q1, q2, q3;
        begin
            q1 = (abs(y2) + abs(y1)) * 0.5 * abs(x2 - x1);
            q2 = (abs(y3) + abs(y2)) * 0.5 * abs(x3 - x2);
            q3 = (abs(y3) + abs(y1)) * 0.5 * abs(x3 - x1);
            bend = abs(q3 - q1 - q2) / ((q1 + q2) * rtol + atol);
        end
    endfunction

    analog function integer straight;
        input x1, y1, x2, y2, x3, y3, rtol, atol;
        real x1, y1, x2, y2, x3, y3, rtol, atol;
        straight = bend(x1, y1, x2, y2, x3, y3, rtol, atol) < 1.0;
    endfunction

    // Quadratic Lagrange weights at t over (t1, t2, t3) (LTRAquadInterp).
    analog function real quadinterp;
        input t, t1, t2, t3;
        output f1, f2, f3;
        real t, t1, t2, t3, f1, f2, f3;
        begin
            quadinterp = 0.0;
            if (t == t1) begin
                f1 = 1.0; f2 = 0.0; f3 = 0.0;
            end else if (t == t2) begin
                f1 = 0.0; f2 = 1.0; f3 = 0.0;
            end else if (t == t3) begin
                f1 = 0.0; f2 = 0.0; f3 = 1.0;
            end else if (t2 - t1 == 0.0 || t3 - t2 == 0.0 || t1 - t3 == 0.0) begin
                f1 = 0.0; f2 = 1.0; f3 = 0.0;
            end else begin
                f1 = (t - t2) * (t - t3);
                f2 = (t - t1) * (t - t3);
                f3 = (t - t1) * (t - t2);
                f1 = f1 / (t1 - t2);
                f2 = f2 / (t2 - t1);
                f2 = f2 / (t2 - t3);
                f3 = f3 / (t2 - t3);
                f1 = f1 / (t1 - t3);
                f3 = f3 / (t1 - t3);
            end
        end
    endfunction

    // ---- setup (LTRAsetup + LTRAtemp) ----
    real imped, admit, td, alpha, beta, atten, cbyr, rclsqr;
    real int_h1, int_h2, int_h3, max_safe_step;
    real xbig, xsmall, xmid, y1small, y1big, y1mid;
    integer iters, done;

    // ---- accepted history (held: see header) ----
    real ht[0:cap-1], hv1[0:cap-1], hv2[0:cap-1], hi1[0:cap-1], hi2[0:cap-1];
    real hb[0:cap-1];                 // bend of the triple centred on each point, 1 <= k <= nh-2
    integer nh, hlo, hm;
    real v10, v20, i10, i20;          // initVolt/initCur snapshot at t = 0
    real brk[0:nbrk-1];               // pending wavefront breakpoints (ring)
    integer brk_head;

    // ---- per-timepoint rebuild (LTRArlcCoeffsSetup / LTRArcCoeffsSetup + ltraload) ----
    real t, tt, c1h1, c1h2, c1h3, in1, in2, yc;
    integer rebuild, tdover, aux, found, i, j, k, doh1, doh2, doh3, drop;
    real lolim1, hilim1, lolim2, hilim2, delta1;
    real h1lov1, h1hiv1, h1dum1, h1dum2, h1relval;
    real h2lov1, h2hiv1, h2dum1, h2lov2, h2hiv2, h2dum2, h2first, h2relval;
    real h3lov1, h3hiv1, h3dum1, h3dum2, h3first, h3relval;
    real alphasqt, expbetat, barg, expterm, coeff, lo, hi, delta;
    real cv1, cv2, ci1, ci2, cw1, cw2, d1, d2;
    real dv1, dv2, di1, di2, f, q1, q2, q3, qd;
    real v1, v2, ib1, ib2, bs, tnext;
    real w1, w2, w3, s1, s2, dtn, dtn1, wmax, wmin;
    integer trip, port, kbest;
    real bk, bmin;

    analog initial begin
        if (wave) begin
            imped = sqrt(l / c);
            admit = 1.0 / imped;
            td = sqrt(l * c) * len;
            alpha = 0.5 * (r / l);
            beta = alpha;
            atten = exp(-beta * td);
            int_h1 = (alpha > 0.0) ? -1.0 : 0.0;
            int_h2 = (alpha > 0.0) ? 1.0 - atten : 0.0;
            int_h3 = (alpha > 0.0) ? -atten : 0.0;
            max_safe_step = 1e99;
            if (rlc && !truncdontcut) begin
                // Largest step over which h2 still looks straight. ngspice
                // sums the SAME h2 check twice; so does this (done == 2).
                xbig = td + 9.0 * td;
                xsmall = td;
                xmid = 0.5 * (xbig + xsmall);
                y1small = rlch2(xsmall, td, alpha, beta);
                iters = 0;
                done = 0;
                while (done != 2 && iters <= 50) begin
                    iters = iters + 1;
                    y1big = rlch2(xbig, td, alpha, beta);
                    y1mid = rlch2(xmid, td, alpha, beta);
                    done = straight(xbig, y1big, xmid, y1mid, xsmall, y1small, compactrel, compactabs)
                         + straight(xbig, y1big, xmid, y1mid, xsmall, y1small, compactrel, compactabs);
                    if (done != 2 && iters <= 50) begin
                        xbig = xmid;
                        xmid = 0.5 * (xbig + xsmall);
                    end
                end
                max_safe_step = xbig - td;
            end
        end else begin
            cbyr = c / r;
            rclsqr = r * c * len * len;
            int_h1 = 0.0;
            int_h2 = 1.0;
            int_h3 = 0.0;
            td = 0.0;
            max_safe_step = 1e99;
        end
    end

    analog begin
        // LTRArlcCoeffsSetup / LTRArcCoeffsSetup + ltraload, once per
        // timepoint: the O(history) walk reads the time, the card and the
        // accepted history only, so Newton iterations read it back (native
        // cache_t).
        (* vera_timepoint *) begin
            t = $abstime;
            c1h1 = 0.0;
            c1h2 = 0.0;
            c1h3 = 0.0;
            in1 = 0.0;
            in2 = 0.0;
            rebuild = analysis("tran") && !analysis("static") && nh > 0;
            if (rebuild) begin
                tt = td;
                j = nh - 1;                                  // native timeindex
                tdover = (t > tt) && (j >= 1);
                // aux = largest i with t - t_i > T.
                aux = 0;
                found = 0;
                if (tdover)
                    for (i = j; i >= 0 && !found; i = i - 1)
                        if (t - ht[i] > tt) begin
                            aux = i;
                            found = 1;
                        end

                // Delayed port values at t - T: quadratic, linear on the first interval.
                dv1 = v10; dv2 = v20; di1 = i10; di2 = i20;
                if (tdover && !rcase) begin
                    i = (aux == j) ? aux - 1 : aux;
                    if (i == 0) begin
                        f = (t - tt - ht[0]) / (ht[1] - ht[0]);
                        dv1 = hv1[0] + f * (hv1[1] - hv1[0]);
                        dv2 = hv2[0] + f * (hv2[1] - hv2[0]);
                        di1 = hi1[0] + f * (hi1[1] - hi1[0]);
                        di2 = hi2[0] + f * (hi2[1] - hi2[0]);
                    end else begin
                        qd = quadinterp(t - tt, ht[i - 1], ht[i], ht[i + 1], q1, q2, q3);
                        dv1 = q1 * hv1[i - 1] + q2 * hv1[i] + q3 * hv1[i + 1];
                        dv2 = q1 * hv2[i - 1] + q2 * hv2[i] + q3 * hv2[i + 1];
                        di1 = q1 * hi1[i - 1] + q2 * hi1[i] + q3 * hi1[i + 1];
                        di2 = q1 * hi2[i - 1] + q2 * hi2[i] + q3 * hi2[i + 1];
                    end
                end

                cv1 = 0.0; cv2 = 0.0; ci1 = 0.0; ci2 = 0.0; cw1 = 0.0; cw2 = 0.0;
                doh1 = 1; doh2 = 1; doh3 = 1;

                if (rlc) begin
                    // First h2/h3 coefficients over [T, t - t_aux] (aux != 0 only).
                    h2first = 0.0; h3first = 0.0;
                    h2lov1 = 0.0; h2hiv1 = 0.0; h2dum1 = 0.0; h2relval = 0.0;
                    h3lov1 = 0.0; h3hiv1 = 0.0; h3dum1 = 0.0; h3relval = 0.0;
                    alphasqt = alpha * alpha * tt;
                    expbetat = exp(-beta * tt);
                    if (aux != 0) begin
                        lo = tt;
                        hi = t - ht[aux];
                        delta = hi - lo;
                        h2lov1 = rlch2(tt, tt, alpha, beta);
                        barg = (hi > tt) ? alpha * sqrt(hi * hi - tt * tt) : 0.0;
                        expterm = exp(barg - beta * hi);
                        h2hiv1 = (alpha == 0.0 || hi < tt) ? 0.0 : alphasqt * expterm * bessi1xoverxe(barg);
                        h2dum1 = twiceintlin(lo, hi, lo, h2lov1, h2hiv1, lo, hi) / delta;
                        h2first = h2dum1;
                        h2relval = abs(chopreltol * h2dum1);
                        h3lov1 = 0.0;
                        h3hiv1 = (hi <= tt || beta == 0.0) ? 0.0 : expterm * bessi0e(barg) - expbetat;
                        h3dum1 = intlin(lo, hi, h3lov1, h3hiv1, lo, hi) / delta;
                        h3first = h3dum1;
                        h3relval = abs(h3dum1 * chopreltol);
                    end

                    // First h1 coefficient over [0, t - t_n].
                    lolim1 = 0.0;
                    hilim1 = t - ht[j];
                    delta1 = hilim1;
                    h1lov1 = 0.0;
                    h1hiv1 = rlch1dash2(hilim1, beta);
                    h1dum1 = h1hiv1 / delta1;
                    c1h1 = h1dum1;
                    h1relval = abs(h1dum1 * chopreltol);

                    // Fused walk newest -> oldest: coefficient and dot product together.
                    // Points newer than t - T (i > aux) carry h1 only, so they get a
                    // loop of their own: VerA if-converts an `if (i <= aux)` inside
                    // one loop, which ran h2/h3's three exp on every point. Same
                    // operations in the same order; doh2 and doh3 stay 1 here.
                    lolim2 = 0.0;
                    hilim2 = 0.0;
                    for (i = j; i > aux; i = i - 1) begin
                        lolim2 = lolim1;
                        hilim2 = hilim1;
                        lolim1 = hilim2;
                        hilim1 = t - ht[i - 1];
                        delta1 = ht[i] - ht[i - 1];
                        if (doh1) begin
                            h1dum2 = h1dum1;
                            h1lov1 = h1hiv1;
                            h1hiv1 = rlch1dash2(hilim1, beta);
                            h1dum1 = (h1hiv1 - h1lov1) / delta1;
                            coeff = h1dum1 - h1dum2;
                            cv1 = cv1 + coeff * (hv1[i] - v10);
                            cv2 = cv2 + coeff * (hv2[i] - v20);
                            if (abs(coeff) <= h1relval) doh1 = 0;
                        end
                    end
                    // aux <= j, so the first loop leaves i == aux.
                    for (i = aux; i > 0 && (doh1 || doh2 || doh3); i = i - 1) begin
                        lolim2 = lolim1;
                        hilim2 = hilim1;
                        lolim1 = hilim2;
                        hilim1 = t - ht[i - 1];
                        delta1 = ht[i] - ht[i - 1];

                        if (doh1) begin
                            h1dum2 = h1dum1;
                            h1lov1 = h1hiv1;
                            h1hiv1 = rlch1dash2(hilim1, beta);
                            h1dum1 = (h1hiv1 - h1lov1) / delta1;
                            coeff = h1dum1 - h1dum2;
                            cv1 = cv1 + coeff * (hv1[i] - v10);
                            cv2 = cv2 + coeff * (hv2[i] - v20);
                            if (abs(coeff) <= h1relval) doh1 = 0;
                        end

                        barg = 0.0;
                        expterm = 0.0;
                        if (doh2 || doh3) begin
                            barg = (hilim1 > tt) ? alpha * sqrt(hilim1 * hilim1 - tt * tt) : 0.0;
                            expterm = exp(barg - beta * hilim1);
                        end
                        if (doh2) begin
                            h2lov2 = h2lov1;
                            h2hiv2 = h2hiv1;
                            h2dum2 = h2dum1;
                            h2lov1 = h2hiv2;
                            h2hiv1 = (alpha == 0.0 || hilim1 < tt) ? 0.0 : alphasqt * expterm * bessi1xoverxe(barg);
                            h2dum1 = twiceintlin(lolim1, hilim1, lolim1, h2lov1, h2hiv1, lolim1, hilim1) / delta1;
                            // ngspice-compatible: at i == aux the (lolim2, hilim2)
                            // interval and the (h2lov2, h2hiv2) values span
                            // different segments (its disabled i == auxindex fix).
                            coeff = h2dum1 - h2dum2 + intlin(lolim2, hilim2, h2lov2, h2hiv2, lolim2, hilim2);
                            ci2 = ci2 + coeff * (hi2[i] - i20);
                            ci1 = ci1 + coeff * (hi1[i] - i10);
                            if (abs(coeff) <= h2relval) doh2 = 0;
                        end
                        if (doh3) begin
                            h3dum2 = h3dum1;
                            h3lov1 = h3hiv1;
                            h3hiv1 = (hilim1 <= tt || beta == 0.0) ? 0.0 : expterm * bessi0e(barg) - expbetat;
                            h3dum1 = intlin(lolim1, hilim1, h3lov1, h3hiv1, lolim1, hilim1) / delta1;
                            coeff = h3dum1 - h3dum2;
                            cw2 = cw2 + coeff * (hv2[i] - v20);
                            cw1 = cw1 + coeff * (hv1[i] - v10);
                            if (abs(coeff) <= h3relval) doh3 = 0;
                        end
                    end

                    // ltraload RLC MODEINITPRED, reference summation order.
                    d1 = cv1 + v10 * int_h1 - v10 * c1h1;
                    d2 = cv2 + v20 * int_h1 - v20 * c1h1;
                    in1 = in1 - d1 * admit;
                    in2 = in2 - d2 * admit;
                    d1 = 0.0;
                    d2 = 0.0;
                    if (tdover) begin
                        d1 = (di2 - i20) * h2first + ci2;
                        d2 = (di1 - i10) * h2first + ci1;
                    end
                    d1 = d1 + i20 * int_h2;
                    d2 = d2 + i10 * int_h2;
                    in1 = in1 + d1;
                    in2 = in2 + d2;
                    d1 = 0.0;
                    d2 = 0.0;
                    if (tdover) begin
                        d1 = (dv2 - v20) * h3first + cw2;
                        d2 = (dv1 - v10) * h3first + cw1;
                    end
                    d1 = d1 + v20 * int_h3;
                    d2 = d2 + v10 * int_h3;
                    in1 = in1 + admit * d1;
                    in2 = in2 + admit * d2;
                    in1 = in1 + atten * (dv2 * admit + di2);
                    in2 = in2 + atten * (dv1 * admit + di1);
                end else if (wave) begin
                    // LC: pure delay.
                    c1h1 = 0.0;
                    in1 = atten * (dv2 * admit + di2);
                    in2 = atten * (dv1 * admit + di1);
                end else begin
                    // RC: three first coefficients over [0, t - t_n].
                    delta1 = t - ht[j];
                    hilim1 = delta1;
                    h1hiv1 = rch1dash2(hilim1, cbyr);
                    h1dum1 = h1hiv1 / delta1;
                    c1h1 = h1dum1;
                    h1relval = abs(h1dum1 * chopreltol);
                    h2hiv1 = rch2int2(hilim1, rclsqr);
                    h2dum1 = h2hiv1 / delta1;
                    c1h2 = h2dum1;
                    h2relval = abs(h2dum1 * chopreltol);
                    h3hiv1 = rch3dash2(hilim1, cbyr, rclsqr);
                    h3dum1 = h3hiv1 / delta1;
                    c1h3 = h3dum1;
                    h3relval = abs(h3dum1 * chopreltol);

                    for (i = j; i > 0 && (doh1 || doh2 || doh3); i = i - 1) begin
                        delta1 = ht[i] - ht[i - 1];
                        hilim1 = t - ht[i - 1];
                        if (doh1) begin
                            h1dum2 = h1dum1;
                            h1lov1 = h1hiv1;
                            h1hiv1 = rch1dash2(hilim1, cbyr);
                            h1dum1 = (h1hiv1 - h1lov1) / delta1;
                            coeff = h1dum1 - h1dum2;
                            cv1 = cv1 + coeff * (hv1[i] - v10);
                            cv2 = cv2 + coeff * (hv2[i] - v20);
                            if (abs(coeff) < h1relval) doh1 = 0;
                        end
                        if (doh2) begin
                            h2dum2 = h2dum1;
                            h2lov1 = h2hiv1;
                            h2hiv1 = rch2int2(hilim1, rclsqr);
                            h2dum1 = (h2hiv1 - h2lov1) / delta1;
                            coeff = h2dum1 - h2dum2;
                            ci2 = ci2 + coeff * (hi2[i] - i20);
                            ci1 = ci1 + coeff * (hi1[i] - i10);
                            if (abs(coeff) < h2relval) doh2 = 0;
                        end
                        if (doh3) begin
                            h3dum2 = h3dum1;
                            h3lov1 = h3hiv1;
                            h3hiv1 = rch3dash2(hilim1, cbyr, rclsqr);
                            h3dum1 = (h3hiv1 - h3lov1) / delta1;
                            coeff = h3dum1 - h3dum2;
                            cw2 = cw2 + coeff * (hv2[i] - v20);
                            cw1 = cw1 + coeff * (hv1[i] - v10);
                            if (abs(coeff) < h3relval) doh3 = 0;
                        end
                    end

                    // ltraload RC MODEINITPRED.
                    d1 = cv1 + v10 * int_h1 - v10 * c1h1;
                    d2 = cv2 + v20 * int_h1 - v20 * c1h1;
                    in1 = in1 - d1;
                    in2 = in2 - d2;
                    d1 = ci2 + i20 * int_h2 - i20 * c1h2;
                    d2 = ci1 + i10 * int_h2 - i10 * c1h2;
                    in1 = in1 + d1;
                    in2 = in2 + d2;
                    d1 = cw2 + v20 * int_h3 - v20 * c1h3;
                    d2 = cw1 + v10 * int_h3 - v10 * c1h3;
                    in1 = in1 + d1;
                    in2 = in2 + d2;
                end
            end

            // Which point a full history drops at this timepoint (LTRAtrunc):
            // the first interior point whose four signals are all collinear
            // with their neighbours; failing that, the oldest when the delayed
            // read no longer reaches it, else the least bent point, so the
            // window t - td stays sampled. It reads t and the accepted history
            // only, so it runs once per timepoint here, not in every Newton
            // evaluation, and reads each point's bend from hb, which the
            // bookkeeping below keeps current. ponytail: lossy past cap
            // (ngspice grows); VerA has no growable held storage.
            drop = 1;
            if (nh == cap && t > ht[nh - 1]) begin
                found = 0;
                bmin = 1e300;
                for (k = 1; k + 1 < nh && !found; k = k + 1) begin
                    bk = hb[k];
                    if (bk < 1.0) begin
                        drop = k;
                        found = 1;
                    end else if (bk < bmin) begin
                        bmin = bk;
                        kbest = k;
                    end
                end
                if (!found && t - ht[4] <= td)
                    drop = kbest;
            end
        end

        v1 = V(br1);
        v2 = V(br2);
        ib1 = I(br1);
        ib2 = I(br2);

        if (!rebuild) begin
            // ngspice MODEDC rows: i1 + i2 = 0; v1 - v2 = R*len*i1.
            V(br1) <+ V(br2) + r * len * I(br1);
            V(br2) <+ V(br2) + I(br1) + I(br2);
        end else begin
            // §1.3 branch rows, solved for the port voltage.
            if (rcase) begin
                V(br1) <+ (I(br1) + c1h2 * I(br2) + c1h3 * V(br2) + in1) / c1h1;
                V(br2) <+ (I(br2) + c1h2 * I(br1) + c1h3 * V(br1) + in2) / c1h1;
            end else begin
                yc = admit * (1.0 + c1h1);
                V(br1) <+ (I(br1) + in1) / yc;
                V(br2) <+ (I(br2) + in2) / yc;
            end
        end

        // ---- accepted-point bookkeeping (LTRAaccept + LTRAtrunc) ----
        // Runs on every evaluation; only an accepted evaluation's result is held.
        // The static solve a transient starts from (§4.6.1: "tran" covers
        // it) seeds the history, as the native t = 0 commit does.
        if (analysis("static")) begin
            nh = 0;
            brk_head = 0;
            for (k = 0; k < nbrk; k = k + 1) brk[k] = -1.0;
        end
        if (nh == 0) begin
            v10 = v1; v20 = v2; i10 = ib1; i20 = ib2;
        end
        hlo = -1;   // first triple a dropped point changed, -1 for none
        if (nh > 0 && t <= ht[nh - 1]) begin
            // Same-time recommit overwrites the tail.
            hv1[nh - 1] = v1; hv2[nh - 1] = v2; hi1[nh - 1] = ib1; hi2[nh - 1] = ib2;
        end else begin
            if (nh == cap) begin
                // Full: drop the point the timepoint block chose.
                for (k = drop; k < cap - 1; k = k + 1) begin
                    ht[k] = ht[k + 1]; hv1[k] = hv1[k + 1]; hv2[k] = hv2[k + 1];
                    hi1[k] = hi1[k + 1]; hi2[k] = hi2[k + 1]; hb[k] = hb[k + 1];
                end
                nh = nh - 1;
                hlo = drop - 1;
            end
            ht[nh] = t; hv1[nh] = v1; hv2[nh] = v2; hi1[nh] = ib1; hi2[nh] = ib2;
            nh = nh + 1;
        end
        // Refresh the bends whose triple changed: the two around a dropped
        // point, and the one centred next to the tail (appended or rewritten).
        for (hm = 0; hm < 3; hm = hm + 1) begin
            k = (hm < 2) ? hlo + hm : nh - 2;
            if (k >= 1 && k + 1 < nh)
                hb[k] = max(max(bend(ht[k - 1], hv1[k - 1], ht[k], hv1[k], ht[k + 1], hv1[k + 1], compactrel, compactabs),
                                bend(ht[k - 1], hv2[k - 1], ht[k], hv2[k], ht[k + 1], hv2[k + 1], compactrel, compactabs)),
                            max(bend(ht[k - 1], hi1[k - 1], ht[k], hi1[k], ht[k + 1], hi1[k + 1], compactrel, compactabs),
                                bend(ht[k - 1], hi2[k - 1], ht[k], hi2[k], ht[k + 1], hi2[k + 1], compactrel, compactabs)));
        end

        // Wavefront breakpoint: when the launched wave (v + Z0 i) changes
        // slope, its image lands one delay after the PREVIOUS point.
        // CHECK()'s tolerances are ngspice's CKTreltol/CKTabstol defaults.
        if (!rcase && nh >= 2) begin
            dtn = ht[nh - 1] - ht[nh - 2];
            dtn1 = (nh >= 3) ? ht[nh - 2] - ht[nh - 3] : 1.0;
            trip = 0;
            for (port = 0; port < 2; port = port + 1) begin
                if (port == 0) begin
                    w1 = (hv1[nh - 1] + hi1[nh - 1] * imped) * atten;
                    w2 = (hv1[nh - 2] + hi1[nh - 2] * imped) * atten;
                    w3 = (nh >= 3) ? (hv1[nh - 3] + hi1[nh - 3] * imped) * atten : w2;
                end else begin
                    w1 = (hv2[nh - 1] + hi2[nh - 1] * imped) * atten;
                    w2 = (hv2[nh - 2] + hi2[nh - 2] * imped) * atten;
                    w3 = (nh >= 3) ? (hv2[nh - 3] + hi2[nh - 3] * imped) * atten : w2;
                end
                s1 = (w1 - w2) / dtn;
                s2 = (nh >= 3) ? (w2 - w3) / dtn1 : 0.0;
                wmax = max(max(w1, w2), w3);
                wmin = min(min(w1, w2), w3);
                if (abs(s1 - s2) >= rel * max(abs(s1), abs(s2)) + brkabs
                    && wmax - wmin >= abs(50.0 * (1e-3 / 3.0 * (w1 + w2 + w3) + 1e-12)))
                    trip = 1;
            end
            if (trip) begin
                brk[brk_head] = ht[nh - 2] + td;
                brk_head = (brk_head + 1 < nbrk) ? brk_head + 1 : 0;
            end
        end

        // Earliest pending breakpoint after now (native nextBreakpoint); a
        // timer is the Verilog-A way to force a timepoint (§5.10.3.3).
        tnext = 1e99;
        for (k = 0; k < nbrk; k = k + 1)
            if (brk[k] > t && brk[k] < tnext) tnext = brk[k];
        @(timer(tnext)) ;

        // §1.7 step control: dt <= td, and the RLC kernel-resolution cap.
        bs = 1e99;
        if (!rcase) begin
            if (steplimit) bs = td;
            if (rlc && !truncdontcut) bs = min(bs, max_safe_step);
        end
        if (bs < 1e99)
            $bound_step(bs);
    end
endmodule
