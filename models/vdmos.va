// VDMOS: vertical power MOSFET (netlist letter M, .model vdmos/vdmosn/vdmosp).
//
// Verilog-A implementation: Omar El-Sawy, University of Waterloo.
// Based on: ngspice vdmos (vdmostemp.c, vdmosload.c; body diode after
// dio/diotemp.c, dioload.c), the ngspice VDMOS power MOSFET model (Holger
// Vogt, Dietmar Warning), on the SPICE3 level-1 MOSFET core.
//   ngspice: Copyright Regents of the University of California and others,
//   modified BSD license.
// Parameter names, units and defaults are ngspice's.
//
// Topology: D-RD-d', G-RG-g', S-RS-s'; channel d'-s' driven by v(g's'); RB
// from S to b' and the body diode b'->D on the external nodes, outside RS
// and RD (vdmosset.c:378-398, vdmosload.c:723-724, 888); the fixed RDS shunt
// across D-S.
// Quasi-saturation (RQ with VQ) grows RD with the external v_ds
// (vdmosload.c:416-432). The channel is the MOS1 three-region core with
// the power-MOS extensions (mobility degradation THETA, triode shaping
// MTRIODE, smooth subthreshold KSUBTHRES/SUBSHIFT) plus the atan/tanh Miller
// capacitance (devsup.c:654-665).
//
// Noise is vdmosnoi.c's: RD and RS thermal, channel thermal (2/3)|gm| and
// KF/AF flicker. RG, RB, RDS and the body diode are noiseless there and here.
// The instance m is m parallel copies throughout: it scales the gate charges
// as ngspice master does (2bc63e, 6bd5c2; 44.2 and 45 leave them unscaled),
// sums the copies' flicker, and scales IBV, which no ngspice version does.
//
// ponytail: no self-heating node (RTHJC/RTHCA/CTHJ belong to the
// electro-thermal variant, a second module); those parameters are still
// declared so cards carrying them bind, and the netlist reader refuses a card
// ngspice would self-heat. Add when a deck needs it.
//
// Junction / fetlim limiting and the MODEINITJCT seed are spelled with $limit
// as in diode.va and mos1.va: $limit stays the identity inside eval, and
// VerA's contract `limit`/`seed` hooks hand the host the clamps to run between
// the linear solve and the next eval.

`include "constants.vams"
`include "disciplines.vams"

module vdmos(d, g, s);
    inout d, g, s;
    electrical d, g, s;
    electrical dp, gp, sp, bp;
    // Series resistances collapse to a short when the parameter is 0,
    // which needs a branch that can carry a voltage contribution.
    branch (d, dp) br_rd;
    branch (g, gp) br_rg;
    branch (s, sp) br_rs;
    branch (s, bp) br_rb;

    // +1 = vdmosn, -1 = vdmosp: ngspice picks the polarity by model name, the
    // eval maps every internal voltage through it.
    parameter integer ty = 1 from [-1:1] exclude 0;

    // --- channel -----------------------------------------------------------
    parameter real vto       = 0.0;              // threshold voltage [V]
    parameter real kp        = 1.0 from (0:inf); // transconductance [A/V^2]
    parameter real lambda    = 0.0 from [0:inf); // channel-length modulation [1/V]
    parameter real theta     = 0.0 from [0:inf); // mobility degradation [1/V]
    parameter real mtriode   = 1.0 from (0:inf); // triode-region conductance knob
    parameter real ksubthres = 0.1 from (0:inf); // subthreshold width [V]
    parameter real subshift  = 0.0;              // subthreshold shift [V]
    // Quasi-saturation acts only with both given (vdmosset.c:211-221).
    parameter real rq        = 0.0 from [0:inf); // quasi-saturation resistance [ohm]
    parameter real vq        = 0.0;              // quasi-saturation voltage, |vq| [V]

    // --- resistances (0 = collapsed, rds 0 = infinite) ---------------------
    parameter real rd   = 0.0 from [0:inf);    // drain resistance [ohm]
    parameter real rg   = 0.0 from [0:inf);    // gate resistance [ohm]
    parameter real rs   = 0.0 from [0:inf);    // source resistance [ohm]
    parameter real rb   = 0.0 from [0:inf);    // body-diode series resistance [ohm]
    parameter real rds  = 0.0 from [0:inf);    // drain-source shunt [ohm]
    parameter real gmin = $simparam("gmin") from [0:inf);  // body-diode conductance floor [S]

    // --- body diode (dioload.c laws) ---------------------------------------
    parameter real is  = 1e-14 from (0:inf);   // saturation current [A]
    parameter real n   = 1.0   from (0:inf);   // emission coefficient
    parameter real bv  = 0.0   from [0:inf);   // reverse breakdown, 0 = none [V]
    parameter real ibv = 1e-10 from [0:inf);   // current at bv [A]
    parameter real nbv = 1.0   from (0:inf);   // breakdown emission coefficient
    parameter real cjo = 5e-10 from [0:inf);   // zero-bias junction cap [F] (vdmosset.c:46-47)
    parameter real vj  = 0.8   from (0:inf);   // junction potential [V]
    parameter real mj  = 0.5   from (0:1);     // grading coefficient (model card key `m`)
    parameter real fc  = 0.5   from (0:1);     // forward-bias cap coefficient
    parameter real tt  = 0.0   from [0:inf);   // transit time [s]
    parameter real eg  = 1.11  from (0:inf);   // IS activation energy [eV]
    parameter real xti = 3.0   from [0:inf);   // IS temperature exponent

    // --- gate capacitances (defaults: vdmosset.c:70-80, only when not given)
    parameter real cgs    = 1.4e-9 from [0:inf);  // gate-source cap [F]
    parameter real cgdmin = 2e-11  from [0:inf);  // minimum gate-drain cap [F]
    parameter real cgdmax = 2e-9   from [0:inf);  // maximum gate-drain cap [F]
    parameter real a      = 1.0 from (0:inf);  // Cgd transition steepness [1/V]

    // --- temperature (vdmostemp.c) -----------------------------------------
    parameter real tnom  = $simparam("tnom");  // nominal temperature, ngspice TNOM [degC]
    parameter real tcvth = 0.0;                // dVTO/dT [V/K]
    parameter real mu    = -1.5;               // KP ~ (T/Tnom)^MU
    parameter real texp0 = 1.5;                // RD (T/Tnom) exponent, when given
    parameter real texp1 = 0.3;                // RQ (T/Tnom) exponent (vdmosset.c:142-146)
    parameter real trd1 = 0.0;  parameter real trd2 = 0.0;
    parameter real trg1 = 0.0;  parameter real trg2 = 0.0;
    parameter real trs1 = 0.0;  parameter real trs2 = 0.0;
    parameter real trb1 = 0.0;  parameter real trb2 = 0.0;
    parameter real tksubthres1 = 0.0;
    parameter real tksubthres2 = 0.0;

    // --- declared for card binding only (see header) -----------------------
    parameter real rthjc = 0.0 from [0:inf);   // electro-thermal variant
    parameter real rthca = 0.0 from [0:inf);
    parameter real cthj  = 0.0 from [0:inf);

    // --- noise (defaults vdmosset.c:64-68) ----------------------------------
    parameter real kf    = 0.0 from [0:inf);   // flicker coefficient
    parameter real af    = 1.0 from (0:inf);   // flicker current exponent

    // --- instance ----------------------------------------------------------
    // beta = KP*W/(L-2*LD)*m. Defaults make W/(L-2LD) = 1 so a
    // datasheet-fitted KP card (no W/L given) keeps meaning KP itself.
    parameter real w  = 1.0 from (0:inf);      // channel width [m]
    parameter real l  = 1.0 from (0:inf);      // drawn channel length [m]
    parameter real ld = 0.0 from [0:inf);      // lateral diffusion [m]
    parameter real m  = 1.0 from (0:inf);      // multiplicity, the instance card's `m`
    // Instance temperature (vdmos.c:19-20, vdmospar.c:33-40,
    // vdmostemp.c:213-216). ngspice 44.2 lets a given `temp` win over
    // dtemp (measured); later ngspice warns and keeps dtemp instead
    // (vdmosset.c:290-294).
    parameter real temp  = 27.0;               // instance temperature [degC]
    parameter real dtemp = 0.0;                // offset from $temperature [K]

    // bias-independent (temperature/parameter prep)
    real tk, tnomk, ratio, dt, vt, vtnom, leff;
    real egfet, egfet1, fact1, fact2, arg1, argt, pbfact, pbfact1;
    real pbo, gmaold, gmanew;
    real vto_t, beta_t, ksub_t;
    real rd_t, rg_t, rs_t, rb_t, rq_t;
    real is_t, vj_t, cjo_t, fcvj, f1, f2, f3, vte, vtebrk, cbv, xbv;
    real cgds, cgdy, tyf, vcritb;
    // Operating-point variables (LRM §3.2.1) under vdmos.c's names (#236),
    // in the n frame (type × each current and voltage) as vdmosask.c reports
    // them: the channel's current and partials in its mode frame, the
    // internal voltages, the body diode's current, charge and capacitance.
    (* desc = "Drain current", units = "A" *) real id;
    (* desc = "Transconductance", units = "S" *) real gm;
    (* desc = "Drain-Source conductance", units = "S" *) real gds;
    (* desc = "Gate-Source voltage", units = "V" *) real vgs;
    (* desc = "Drain-Source voltage", units = "V" *) real vds;
    (* desc = "Body diode current", units = "A" *) real idio;
    (* desc = "Body diode charge", units = "C" *) real qdio;
    (* desc = "Drain-Source capacitance", units = "F" *) real cds;
    // bias-dependent
    real vdsi, vgd, vgdi, msign, vdse, vgst, vgste, sarg, betaeff;
    real vknee, idch, dvgste, gmn, coxn, grd, rdq, vdsn;
    real vd, ibd, qbd, arg, argc, qgd, ax;

    // Resistance temperature curve: quadratic in dT times a (T/Tnom)
    // exponent, floored. ngspice clamps a resistance that the curve drove to
    // zero or negative; without the floor the stamps below divide by <= 0.
    analog function real rtemp;
        input r, tc1, tc2, dtx, ratiox, ex;
        real r, tc1, tc2, dtx, ratiox, ex;
        real rr;
        begin
            rr = r * (1.0 + tc1 * dtx + tc2 * dtx * dtx) * pow(ratiox, ex);
            if (rr < 1.0e-9) rr = 1.0e-9;
            rtemp = rr;
        end
    endfunction

    analog begin
        // ---- bias-independent prep -----------------------------------------
        if ($param_given(temp)) tk = temp + 273.15;
        else tk = $temperature + dtemp;
        tnomk = tnom + 273.15;
        ratio = tk / tnomk;
        dt = tk - tnomk;
        vt = 1.38064852e-23 / 1.6021766208e-19 * tk;
        vtnom = 1.38064852e-23 / 1.6021766208e-19 * tnomk;

        // Threshold, mapped through ty: an ngspice vdmosp card carries a
        // negative Vto and the whole channel is evaluated in the ty frame, so
        // the threshold enters that frame too (as mos1.va's
        // `von = vbit*type + ...`). TCVTH does not flip with it: von =
        // type*(VTO - type*TCVTH*dT) (vdmostemp.c:50, vdmosload.c:351).
        vto_t = ty * vto - tcvth * dt;
        leff = l - 2.0 * ld;
        // ponytail: silent clamp, no diagnostics channel in this frontend
        // (mos1.va does the same for LD >= L/2).
        if (leff < 1.0e-10) leff = 1.0e-10;
        beta_t = kp * pow(ratio, mu) * m * w / leff;
        ksub_t = ksubthres * (1.0 + tksubthres1 * dt + tksubthres2 * dt * dt);

        // vdmostemp.c:54-64: RD goes as (T/Tnom)^TEXP0 when TEXP0 is given,
        // else by its TRD1/TRD2 polynomial; RQ as (T/Tnom)^TEXP1; RS, RG and
        // RB by their polynomials only. The fixed d-s shunt RDS is flat.
        if ($param_given(texp0)) rd_t = rtemp(rd, 0.0, 0.0, dt, ratio, texp0);
        else rd_t = rtemp(rd, trd1, trd2, dt, ratio, 0.0);
        rq_t = rq * pow(ratio, texp1);
        rg_t = rtemp(rg, trg1, trg2, dt, ratio, 0.0);
        rs_t = rtemp(rs, trs1, trs2, dt, ratio, 0.0);
        rb_t = rtemp(rb, trb1, trb2, dt, ratio, 0.0);

        // ---- body-diode temperature (diotemp.c) ----------------------------
        // IS(T) uses the EG *parameter* (activation energy) ...
        is_t = is * m * exp((ratio - 1.0) * eg / (n * vt) + (xti / n) * ln(ratio));
        // ... while VJ(T) and CJ0(T) use the temperature-dependent silicon
        // bandgap through the pbfact/pbo construction referred to 300.15 K.
        // Same code as mos1.va (`pbfact1/pbfact/pbo/pbt`, `cfb`).
        egfet1 = 1.16 - (7.02e-4 * tnomk * tnomk) / (tnomk + 1108.0);
        egfet  = 1.16 - (7.02e-4 * tk * tk) / (tk + 1108.0);
        fact1 = tnomk / 300.15;
        fact2 = tk / 300.15;
        arg1 = -egfet1 / (2.0 * 1.38064852e-23 * tnomk)
             + 1.1150877 / (2.0 * 1.38064852e-23 * 300.15);
        argt = -egfet / (2.0 * 1.38064852e-23 * tk)
             + 1.1150877 / (2.0 * 1.38064852e-23 * 300.15);
        pbfact1 = -2.0 * vtnom * (1.5 * ln(fact1) + 1.6021766208e-19 * arg1);
        pbfact  = -2.0 * vt * (1.5 * ln(fact2) + 1.6021766208e-19 * argt);
        pbo = (vj - pbfact1) / fact1;
        vj_t = fact2 * pbo + pbfact;
        gmaold = (vj - pbo) / pbo;
        gmanew = (vj_t - pbo) / pbo;
        cjo_t = cjo * m * (1.0 + mj * (4.0e-4 * (tk - 300.15) - gmanew))
                         / (1.0 + mj * (4.0e-4 * (tnomk - 300.15) - gmaold));

        vte = n * vt;
        vtebrk = nbv * vt;
        fcvj = fc * vj_t;
        f1 = vj_t * (1.0 - pow(1.0 - fc, 1.0 - mj)) / (1.0 - mj);
        f2 = pow(1.0 - fc, 1.0 + mj);              // e^{(1+M)*x_fc}
        f3 = 1.0 - fc * (1.0 + mj);

        // Breakdown matching (diotemp.c): solve the effective x_bv so the
        // breakdown exponential passes through (-x_bv, -c_bv). BV(T) = BV:
        // VDMOS has no BV temperature coefficient (no TCV parameter), so the
        // tlev=0 form BV - t_cv*dT degenerates to BV.
        // ponytail: fixed 25 sweeps, no tolerance early-exit; 25 is diotemp.c's
        // iteration cap, it converges in ~3, and this is bias-independent prep.
        // The ln argument stays > 1 (x_bv < BV and c_bv/IS > BV/Vt in this arm),
        // so it is always in range. IBV is one copy's, so c_bv = m*IBV as IS is
        // m*IS and as the diode's is (diotemp.c:211-213): x_bv is then one
        // copy's. ngspice 44.2, 45 and master take IBV unscaled (45's
        // vdmostemp.c:136), so their x_bv moves by about nbv*Vt*ln(m).
        xbv = 0.0;
        if (bv > 0.0) begin
            cbv = m * ibv;
            if (cbv < is_t * bv / vt) begin
                cbv = is_t * bv / vt;
                xbv = bv;
            end else begin
                xbv = bv - vtebrk * ln(1.0 + cbv / is_t);
                repeat (25)
                    xbv = bv - vtebrk * ln(cbv / is_t + 1.0 - xbv / vt);
            end
        end

        cgds = (cgdmax - cgdmin) / (1.0 + `M_PI / 2.0);  // devsup.c:658-659
        cgdy = cgdmax - cgds;

        // ---- terminal resistances (collapse when the parameter is 0) -------
        // The guard is on the raw parameter: node collapse is a topology
        // decision, so it must not depend on temperature. The divisor is the
        // floored rtemp() value, which is never <= 0.
        // RD (below, with quasi-saturation) and RS thermal noise 4kT*g
        // (vdmosnoi.c:102-108), VDMOSsourceConductance = m/rs(T)
        // (vdmostemp.c:61). T is the circuit's, not the instance's:
        // NevalSrc's THERMNOISE reads CKTtemp (nevalsrc.c:110-111) and
        // tempRatioSH is 1 without self-heating.
        if (rg > 0.0) I(br_rg) <+ m * V(br_rg) / rg_t; else V(br_rg) <+ 0.0;
        if (rs > 0.0)
            I(br_rs) <+ m * V(br_rs) / rs_t
                      + white_noise(4.0 * 1.38064852e-23 * $temperature * m / rs_t, "rs");
        else V(br_rs) <+ 0.0;
        if (rb > 0.0) I(br_rb) <+ m * V(br_rb) / rb_t; else V(br_rb) <+ 0.0;

        // ---- channel, limited as in mos1.va --------------------------------
        // fetlim on both channel gate legs, limvds on the channel Vds, pnjlim
        // on the body diode below. vto_t is already the ty-frame threshold;
        // trailing tyf = VerA frame sign (vdmosp limits ty*v), and tyf is ty
        // as a real because integer $limit args are declined.
        tyf  = ty;
        vgs  = ty * $limit(V(gp, sp), "fetlim", vto_t, tyf);
        vgdi = ty * $limit(V(gp, dp), "fetlim", vto_t, tyf);
        vdsi = ty * $limit(V(dp, sp), "limvds", tyf);  // seen by the channel
        vds  = ty * V(dp, sp);                     // the same, unlimited
        vgd  = vgs - vds;
        vgdi = vgs - vdsi;

        // ---- RD with quasi-saturation (vdmosload.c:416-432) ----------------
        // VDMOSdrainConductance is 1/rd0T, rd0T = rd(T)/m. With RQ and VQ
        // both given (vdmosset.c:217-218) and the channel forward (mode 1),
        // it is 1/rd + gmin, rd = rd0T + rd1T*vdsn/(vdsn + |VQ|), rd1T =
        // RQ(T)/m and vdsn the external d-s voltage: RD grows toward RD + RQ
        // as vds rises (:419-423). An rd <= 0 falls back to 1/rd0T
        // (:425-427). Without RD ngspice makes no d' (vdmosset.c:307-327), so
        // RQ and VQ do nothing there either. Thermal noise 4kT*g on the same g
        // (vdmosnoi.c:102-104).
        // ngspice reads vdsn off the previous iterate, which leaves the same
        // fixed point but no d(rd)/d(vds) in its AC and noise matrices; this
        // conductance's vds slope is in ours, so with RQ active the small
        // signal differs from ngspice's by that term.
        if (rd > 0.0) begin
            grd = m / rd_t;
            if ($param_given(rq) && $param_given(vq) && vdsi >= 0.0) begin
                vdsn = ty * V(d, s);
                rdq = rd_t + rq_t * vdsn / (vdsn + abs(vq));
                if (rdq > 0.0) grd = m / rdq + gmin;
            end
            I(br_rd) <+ grd * V(br_rd)
                      + white_noise(4.0 * 1.38064852e-23 * $temperature * grd, "rd");
        end else V(br_rd) <+ 0.0;

        // Mode swap as MOS1: source and drain exchange roles for vds < 0.
        if (vdsi >= 0.0) begin
            msign = 1.0;
            vdse = vdsi;
            vgst = vgs - vto_t;
        end else begin
            msign = -1.0;
            vdse = -vdsi;
            vgst = vgdi - vto_t;
        end

        // Smooth subthreshold overdrive: ksub*ln(1+exp(x/ksub)) -> x for x>>0,
        // the large-argument arm only avoids exp() overflow (error < 1e-13).
        sarg = (vgst - subshift) / ksub_t;
        if (sarg > 30.0)
            vgste = vgst - subshift;
        else
            vgste = ksub_t * ln(1.0 + exp(sarg));

        betaeff = beta_t / (1.0 + theta * vgste);        // mobility degradation

        // Three-region core. MTRIODE scales the linear-region conductance and
        // pulls the knee to vgste/mtriode, which keeps I and dI/dvds continuous.
        vknee = vgste / mtriode;
        if (vdse < vknee)
            idch = betaeff * mtriode * vdse * (vgste - 0.5 * mtriode * vdse);
        else
            idch = 0.5 * betaeff * vgste * vgste;
        // vdmosload.c:366 (45): t0 = 1 + lambda*vds on the signed ty-frame
        // vds, so a reversed channel carries less current (ngspice 44.2:
        // 0.95x at vds = -0.5 V, lambda 0.1). ngspice's gds keeps +lambda's
        // slope in reverse mode (:370, 381, 388) where this exact slope is
        // its negative: the same DC point, a reverse-mode AC that differs
        // from ngspice's by twice that term.
        idch = idch * (1.0 + lambda * vdsi);

        I(dp, sp) <+ ty * msign * idch;
        // vdmosload.c:423 VDMOScd = mode * cdrain; gm and gds are dcdrain
        // over the mode frame's gate and drain voltages (vdmosload.c:385-392),
        // whose source is s' forward and d' reversed.
        id = msign * idch;
        gm = ty * ddx(idch, V(gp));
        if (msign > 0.0) gds = ty * ddx(idch, V(dp));
        else gds = ty * ddx(idch, V(sp));
        // vdmosset.c:292-299: the d-s shunt sits on the external nodes and is
        // m/RDS, or 1e-15 S without RDS; gmin goes on the body diode only
        // (vdmosload.c:808).
        I(d, s) <+ (rds > 0.0 ? m / rds : 1e-15) * V(d, s);

        // ---- channel noise (vdmosnoi.c:110-117) ----------------------------
        // Thermal 4kT*(2/3)|gm| and flicker of m parallel copies, each
        // KF*|cd/m|^AF / (f*cox^2), with cd = mode*cdrain (vdmosload.c:402);
        // cd and gm carry m through beta. ngspice 44.2 and 45 divide
        // KF*|cd|^AF by m, master (2bc63e) by nothing. The copies' sum is
        // KF*|cd|^AF*m^(1-AF): m^(1-AF) times master's (equal at AF = 1) and
        // m^(2-AF) times 44.2's and 45's (equal at AF = 2).
        // cox is a 1e-7 m oxide's: vdmosset.c:233 always sets
        // VDMOSoxideCapFactor to it, and vdmosnoi.c:55-60 squares it.
        // gm by hand: the mode-frame d(idch)/d(vgst), VDMOSgm of
        // vdmosload.c:373-387 taken of this file's idch. VerA's noisePsd
        // evaluates on unseeded values, so ddx() (the gm op var) reads 0 here.
        dvgste = (sarg > 30.0) ? 1.0 : exp(sarg) / (1.0 + exp(sarg));
        gmn = ((vdse < vknee) ? betaeff * mtriode * vdse : betaeff * vgste)
                * (1.0 + lambda * vdsi) * dvgste
            - idch * theta / (1.0 + theta * vgste) * dvgste;
        coxn = 3.9 * 8.854214871e-12 / 1.0e-7;
        I(dp, sp) <+ white_noise(4.0 * 1.38064852e-23 * $temperature * 2.0 / 3.0 * abs(gmn), "id");
        I(dp, sp) <+ flicker_noise(m * kf * pow(max(abs(idch) / m, 1.0e-38), af) / (coxn * coxn),
                                   1.0, "1overf");

        // ---- body diode b'->d, RB from s to b' (vdmosload.c:723, 888) -----
        // dioload.c, all three regions: Shockley forward, the smooth cubic
        // deep-reverse branch (C1 with the forward branch at -3*Vte, and its
        // conductance does not collapse to gmin while blocking), and the
        // breakdown exponential below -x_bv. pnjlim'd as in diode.va, with
        // vcrit = vte*ln(vte/(sqrt(2)*Is)); limexp is already tangent-
        // continued, so no flat-clamp hazard in either exponential.
        vcritb = vte * ln(vte / (1.4142135623730951 * is_t));
        vd = ty * $limit(V(bp, d), "pnjlim", vte, vcritb, tyf);
        if (vd >= -3.0 * vte)
            ibd = is_t * (limexp(vd / vte) - 1.0);
        else if (bv <= 0.0 || vd >= -xbv) begin
            argc = 3.0 * vte / (vd * 2.718281828459045);
            ibd = -is_t * (1.0 + argc * argc * argc);
        end else
            ibd = -is_t * limexp(-(xbv + vd) / vtebrk);
        ibd = ibd + gmin * vd;

        if (vd < fcvj) begin
            arg = 1.0 - vd / vj_t;
            qbd = cjo_t * vj_t * (1.0 - pow(arg, 1.0 - mj)) / (1.0 - mj);
        end else begin
            qbd = cjo_t * f1 + cjo_t / f2 *
                  (f3 * (vd - fcvj) + 0.5 * mj / vj_t * (vd * vd - fcvj * fcvj));
        end
        qbd = qbd + tt * ibd;                            // diffusion charge
        I(bp, d) <+ ty * ibd + ty * ddt(qbd);
        // vdmosask.c:38-40, 119-130: VDIOcap = dq/dvd, VDIOcurrent, the charge.
        idio = ibd;
        qdio = qbd;
        cds = ty * ddx(qbd, V(bp));

        // ---- gate charges (devsup.c:654-665, vdmosload.c:475-519) ---------
        // Cgd = s*atan(a*vgd) + y for vgd <= 0 and s*tanh(a*vgd) + y above,
        // s = (cgdmax-cgdmin)/(1+pi/2), y = cgdmax-s. q_gd is its exact
        // integral, so charge is conserved; ngspice accumulates q += C*dv with
        // C the trapezoid of the step's two ends, which converges to it. With
        // x = a*vgd: x*atan(x) - ln(1+x^2)/2 below 0, ln(cosh(x)) above,
        // written overflow-free as x + ln1p(e^-2x) - ln 2. Both charges are
        // m parallel copies', as in ngspice master (2bc63e, 6bd5c2); 44.2 and
        // 45 leave the caps unscaled (vdmosload.c:71-74), a bug master fixed.
        ax = a * vgd;
        if (ax <= 0.0)
            qgd = cgdy * vgd + cgds * (ax * atan(ax) - 0.5 * ln1p(ax * ax)) / a;
        else
            qgd = cgdy * vgd + cgds * (ax + ln1p(exp(-2.0 * ax)) - 0.6931471805599453) / a;

        I(gp, sp) <+ ty * ddt(m * cgs * vgs);
        I(gp, dp) <+ ty * ddt(m * qgd);
    end
endmodule
