// MOS3: semi-empirical short-channel MOSFET (netlist letter M, LEVEL=3).
//
// Verilog-A implementation: Omar El-Sawy, University of Waterloo.
// Based on: ngspice mos3 (mos3.c, mos3temp.c, mos3load.c, mos3noi.c), the
// Berkeley SPICE2/SPICE3 level-3 semi-empirical MOSFET (Dang short-channel
// depletion sharing, Meyer gate capacitances).
//   ngspice: Copyright Regents of the University of California and others,
//   modified BSD license.
//
// Laid out section for section like mos1.va; the parameter set and the drain
// current section are what differ.
//
// Topology:   d --RD-- di --channel-- si --RS-- s
//             g --Meyer caps--> di, si, b        b --junction diodes--> di, si
//
// gm/gds/gmbs and every cap conductance come from differentiating the value
// chain (AD backend), so ngspice's d*/dv* bookkeeping is not transcribed; the
// one exception is gdsat in the CLM block, which ngspice writes in closed form.

`include "constants.vams"
`include "disciplines.vams"

module mos3(d, g, s, b);
    inout d, g, s, b;
    electrical d, g, s, b;
    electrical di, si;              // internal drain/source behind rd/rs

    // ---- polarity -------------------------------------------------------
    parameter integer type     = 1 from [-1:1] exclude 0;  // +1 NMOS, -1 PMOS

    // ---- channel (level 3) ---------------------------------------------
    parameter integer tpg      = 1 from [-1:1];            // gate: +1 opp, -1 same, 0 aluminium
    parameter real    vto    = 0.0;                      // zero-bias threshold [V]
    aliasparam vt0 = vto;                    // ngspice mos3.c:115 IOPR spelling
    parameter real    kp     = 2.07189e-5 from (0:inf);  // transconductance [A/V^2]
    parameter real    gamma  = 0.0 from [0:inf);         // body effect [sqrt(V)]
    parameter real    phi    = 0.6 from (0:inf);         // surface potential [V]
    parameter real    nsub   = 0.0 from [0:inf);         // substrate doping [cm^-3]
    parameter real    nss    = 0.0 from [0:inf);         // surface state density [cm^-2]
    parameter real    nfs    = 0.0 from [0:inf);         // fast surface state density [cm^-2]
    parameter real    eta    = 0.0;                      // static feedback (DIBL)
    parameter real    delta  = 0.0;                      // narrow-width factor
    parameter real    theta  = 0.0;                      // mobility degradation [1/V]
    parameter real    kappa  = 0.2;                      // channel-length modulation
    parameter real    u0     = 600.0 from (0:inf);       // low-field mobility [cm^2/Vs]
    aliasparam uo = u0;
    parameter real    vmax   = 0.0 from [0:inf);         // max drift velocity [m/s]
    parameter real    xj     = 0.0 from [0:inf);         // junction depth [m]
    parameter real    xd     = 0.0 from [0:inf);         // depletion coeff (= sqrt(alpha)) [m/sqrt(V)]
    parameter real    alpha  = 0.0 from [0:inf);         // 2*eps_si/(q*Nsub) [m^2/V]
    parameter real    delvto = 0.0;                      // threshold adjust [V]
    aliasparam delvt0 = delvto;

    // ---- instance, with the LD/XL/WD/XW/TOX geometry adjustments ---------
    parameter real    l   = 1e-4 from (0:inf);  // drawn length [m]
    parameter real    w   = 1e-4 from (0:inf);  // drawn width [m]
    parameter real    ld  = 0.0;                // lateral diffusion [m]
    parameter real    xl  = 0.0;                // length mask adjust [m]
    parameter real    wd  = 0.0;                // width narrowing [m]
    parameter real    xw  = 0.0;                // width mask adjust [m]
    parameter real    tox = 1e-7 from (0:inf);  // oxide thickness [m]
    parameter real    ad  = 0.0 from [0:inf);   // drain area [m^2]
    parameter real    as  = 0.0 from [0:inf);   // source area [m^2]
    parameter real    pd  = 0.0 from [0:inf);   // drain perimeter [m]
    parameter real    ps  = 0.0 from [0:inf);   // source perimeter [m]
    parameter real    m   = 1.0 from (0:inf);   // parallel multiplier

    // ---- series resistance ---------------------------------------------
    parameter real    rd  = 0.0 from [0:inf);  // drain resistance [Ohm]
    parameter real    rs  = 0.0 from [0:inf);  // source resistance [Ohm]
    parameter real    rsh = 0.0 from [0:inf);  // sheet resistance [Ohm/square]
    parameter real    nrd = 1.0 from [0:inf);  // squares, drain
    parameter real    nrs = 1.0 from [0:inf);  // squares, source

    // ---- bulk junctions ------------------------------------------------
    parameter real    is   = 1e-14 from [0:inf);  // saturation current [A]
    parameter real    js   = 0.0 from [0:inf);    // saturation current density [A/m^2]
    parameter real    pb   = 0.8 from (0:inf);    // junction potential [V]
    parameter real    fc   = 0.5 from (0:1);      // forward-bias cap factor
    parameter real    cbd  = 0.0 from [0:inf);    // b-d zero-bias cap [F]
    parameter real    cbs  = 0.0 from [0:inf);    // b-s zero-bias cap [F]
    parameter real    cj   = 0.0 from [0:inf);    // bottom cap [F/m^2]
    parameter real    cjsw = 0.0 from [0:inf);    // sidewall cap [F/m]
    parameter real    mj   = 0.5 from (0:1);      // bottom grading
    parameter real    mjsw = 0.33 from (0:1);     // sidewall grading
    parameter real    gmin = $simparam("gmin") from [0:inf);  // junction conductance floor [S]

    // ---- gate overlap capacitance --------------------------------------
    parameter real    cgso = 0.0 from [0:inf);  // gate-source overlap [F/m]
    parameter real    cgdo = 0.0 from [0:inf);  // gate-drain overlap [F/m]
    parameter real    cgbo = 0.0 from [0:inf);  // gate-bulk overlap [F/m]

    // ---- noise ---------------------------------------------------------
    parameter real    kf = 0.0 from [0:inf);  // flicker coefficient
    parameter real    af = 1.0 from (0:inf);  // flicker exponent
    parameter integer nlev = 2 from [0:3];    // noise model selection
    parameter real    gdsnoi = 1.0 from [0:inf);  // channel shot noise coefficient (NLEV=3)

    // ---- temperature ---------------------------------------------------
    parameter real    tnom  = $simparam("tnom");  // parameter measurement temp [degC]
    parameter real    temp  = 27.0;               // explicit device temp override [degC]
    parameter real    dtemp = 0.0;                // instance offset from $temperature [K]

    // bias-independent
    real nitnom, tk, tnomk, vt, vtnom, vt300, ratio, egfet, egfet1, fact1, fact2;
    real pbfact1, pbfact, pbo, gmaold, gmanew, cfb, cfsw;
    real phix, gammax, vtox, kpx, fermis, fermig, wkfng, wkfngs;
    real phit, sqphit, pbt, vbit;
    real ist, jst, coxp, leff, weff, beta, u0t, kpt, fnarrow, etas, alph, xdw;
    real ldxj, xjleff, cscox, rdt, rst, gdrain, gsource, cgsov, cgdov, cgbov;
    real czbs, czbd, czbssw, czbdsw, isats, isatd;
    // bias-dependent
    real ty, vcrits, vcritd, vgs, vgd, vds, vbs, vbd, vbsr, mode, vgsx, vdsx, vbx;
    real sarg, phibs, wps, wpxj, wcxj, arga, argb, argc, fshort;
    real gammas, fbody, qbonco, vbix, vth, xn, von, vgseff;
    real onfg, fgate, avds, vdsc, vdsat, vdson, cdo, id, fdrain;
    real gdsat, emax, delxl, clfact, gmch, sid, alphan, fln, wn, ln_;
    real ibs, ibd, qbs, qbd;
    real vgst, vdsp, cgsh, cgdh, cgbh, chgs, chgd, capgs, capgd, capgb;
    real pcapgs, pcapgd, pcapgb, vgsf, vgdf, vgbf;

    // Bulk junction current: MOS3's reverse branch is the (3Vt/(v*e))^3 form
    // (mos3load.c), not MOS1's flat -Isat. The forward exp is tangent-continued
    // above 80*vtx: a flat clamp there would zero the restoring slope on evals
    // at unlimited x (LTE probes, sweep warm starts).
    analog function real jcur;
        input v, isat, vtx, gm;
        real v, isat, vtx, gm;
        real arg, u;
        begin
            if (v > -3.0 * vtx) begin
                u = min(v / vtx, 80.0);
                jcur = isat * (exp(u) * (1.0 + (v / vtx - u)) - 1.0) + gm * v;
            end else begin
                arg = 3.0 * vtx / (v * 2.718281828459045);
                jcur = -isat * (1.0 + arg * arg * arg) + gm * v;
            end
        end
    endfunction

    // Junction depletion charge: power law below fc*pb(T), f1/f2/f3 quadratic
    // above (mos1temp.c forward-bias linearization). `pj` is the
    // temperature-mapped potential, so V_depcap = fc*pb(T) falls out.
    analog function real qdep;
        input v, cj0, pj, mg, fcj;
        real v, cj0, pj, mg, fcj;
        real f1, f2, f3;
        begin
            if (cj0 <= 0.0) begin
                qdep = 0.0;
            end else if (v < fcj * pj) begin
                qdep = (cj0 * pj / (1.0 - mg)) *
                        (1.0 - pow(1.0 - v / pj, 1.0 - mg));
            end else begin
                f1 = (cj0 * pj / (1.0 - mg)) * (1.0 - pow(1.0 - fcj, 1.0 - mg));
                f2 = pow(1.0 - fcj, 1.0 + mg);
                f3 = 1.0 - fcj * (1.0 + mg);
                qdep = f1 + (cj0 / f2) *
                        (f3 * (v - fcj * pj) +
                         (mg / (2.0 * pj)) * (v * v - fcj * fcj * pj * pj));
            end
        end
    endfunction

    analog begin
        // ============ parameter defaulting (mos3temp.c) ====================
        // "Given" is $param_given: every default here is also a legal card value.
        tnomk  = tnom + 273.15;
        vtnom  = tnomk * (1.38064852e-23 / 1.6021766208e-19);
        egfet1 = 1.16 - 7.02e-4 * tnomk * tnomk / (tnomk + 1108.0);
        coxp   = 3.9 * 8.854214871e-12 / tox;      // F/m^2, oxideCapFactor

        // NSUB defaults phi, gamma, then VTO via the flat band.
        phix   = phi;
        gammax = gamma;
        vtox   = vto;
        // ni at TNOM (mos3temp.c:50-54), the doping-derived PHI's reference.
        nitnom = 1.45e16 * (tnomk / 300.0) * sqrt(tnomk / 300.0)
                 * exp(0.5 * egfet1 * (1.0 / 300.0 - 1.0 / tnomk) / (1.38064852e-23 / 1.6021766208e-19));
        if ($param_given(nsub) && nsub * 1e6 > nitnom) begin
            if (!$param_given(phi))
                phix = max(0.1, 2.0 * vtnom * ln(nsub * 1e6 / nitnom));
            if (!$param_given(gamma))
                gammax = sqrt(2.0 * 11.7 * 8.854214871e-12
                              * 1.6021766208e-19 * nsub * 1e6) / coxp;
            if (!$param_given(vto)) begin
                fermis = type * 0.5 * phix;
                if (tpg != 0) begin                 // poly gate
                    fermig = tpg * type * 0.5 * egfet1;
                    wkfng  = 3.25 + 0.5 * egfet1 - fermig;
                end else begin
                    wkfng  = 3.2;                   // aluminium gate
                end
                wkfngs = wkfng - (3.25 + 0.5 * egfet1 + fermis);
                vtox   = wkfngs - 1.6021766208e-19 * nss * 1e4 / coxp
                         + type * (gammax * sqrt(phix) + phix);
            end
        end
        // KP is always Cox'-derived unless the card gives it (mos3temp.c).
        if ($param_given(kp)) kpx = kp; else kpx = u0 * coxp * 1e-4;

        // Depletion-layer coefficient: alpha = 2*eps_si/(q*Nsub) [Nsub in m^-3],
        // xd = sqrt(alpha); both are card-settable overrides (mos3.c).
        if ($param_given(alpha))
            alph = alpha;
        else if (nsub > 0.0)
            alph = 2.0 * 11.7 * 8.854214871e-12
                   / (1.6021766208e-19 * nsub * 1e6);
        else
            alph = 0.0;
        if ($param_given(xd)) xdw = xd; else xdw = sqrt(alph);

        // ============ temperature scaling (mos3temp.c) =====================
        // Device temperature is the simulator's plus the instance offset, unless
        // the instance gives TEMP explicitly (ngspice CKTtemp + dtemp rule).
        if ($param_given(temp)) tk = temp + 273.15;
        else tk = $temperature + dtemp;
        vt    = tk * (1.38064852e-23 / 1.6021766208e-19);
        vt300 = 300.15 * (1.38064852e-23 / 1.6021766208e-19);
        ratio = tk / tnomk;
        fact1 = tnomk / 300.15;
        fact2 = tk / 300.15;
        egfet = 1.16 - 7.02e-4 * tk * tk / (tk + 1108.0);
        // SPICE intrinsic shift (mos1temp.c): the bandgap terms are part of
        // pbfact, dropping them biases phi(T)/pb(T) by Eg(T) - r*Eg(Tnom).
        pbfact1 = -2.0 * vtnom * (1.5 * ln(fact1)
                  - egfet1 / (2.0 * vtnom) + 1.1150877 / (2.0 * vt300));
        pbfact  = -2.0 * vt * (1.5 * ln(fact2)
                  - egfet / (2.0 * vt) + 1.1150877 / (2.0 * vt300));

        phit   = fact2 * (phix - pbfact1) / fact1 + pbfact;
        sqphit = sqrt(phit);
        pbt    = fact2 * (pb - pbfact1) / fact1 + pbfact;

        kpt = kpx / pow(ratio, 1.5);
        u0t = u0 / pow(ratio, 1.5);
        ist = is * exp(-egfet / vt + egfet1 / vtnom);
        jst = js * exp(-egfet / vt + egfet1 / vtnom);

        // vbi(T) as in mos1.va; DELVTO shifts VTO once, here.
        vbit = vtox + delvto - type * gammax * sqrt(phix)
               + 0.5 * (egfet1 - egfet) + type * 0.5 * (phit - phix);

        // Two-stage 1+MJ(4e-4 dT - gamma_ma) junction-cap temperature factor.
        pbo    = (pb - pbfact1) / fact1;
        gmaold = (pb - pbo) / pbo;
        gmanew = (pbt - pbo) / pbo;
        cfb    = (1.0 + mj * (4e-4 * (tk - 300.15) - gmanew))
                 / (1.0 + mj * (4e-4 * (tnomk - 300.15) - gmaold));
        cfsw   = (1.0 + mjsw * (4e-4 * (tk - 300.15) - gmanew))
                 / (1.0 + mjsw * (4e-4 * (tnomk - 300.15) - gmaold));

        // ============ geometry, junction sizing ===========================
        leff = max(l - 2.0 * ld + xl, 1e-9);
        weff = max(w - 2.0 * wd + xw, 1e-9);
        beta = kpt * weff / leff;

        fnarrow = delta * 3.14159265358979 * 11.7 * 8.854214871e-12
                  / (2.0 * coxp * weff);
        etas    = eta * 8.15e-22 / (coxp * leff * leff * leff);

        // Dang short-channel sharing needs both xj and the depletion width.
        if (xj > 0.0 && xdw > 0.0) begin
            ldxj   = ld / xj;
            xjleff = xj / leff;
        end else begin
            ldxj   = 0.0;
            xjleff = 0.0;
        end

        if (nfs > 0.0)
            cscox = 1.6021766208e-19 * nfs * 1e4 / coxp;
        else
            cscox = 0.0;

        cgsov = cgso * weff * m;
        cgdov = cgdo * weff * m;
        cgbov = cgbo * leff * m;

        // Junction caps: absolute CBD/CBS if given, else CJ*area (+ CJSW*perim).
        if (cbs > 0.0) czbs = cbs * cfb * m; else czbs = cj * cfb * as * m;
        if (cbd > 0.0) czbd = cbd * cfb * m; else czbd = cj * cfb * ad * m;
        czbssw = cjsw * cfsw * ps * m;
        czbdsw = cjsw * cfsw * pd * m;

        // JS wins only when BOTH areas are given: ngspice decides once for the
        // pair (mos3load.c), not per junction.
        if (js > 0.0 && ad > 0.0 && as > 0.0) begin
            isats = jst * as * m;
            isatd = jst * ad * m;
        end else begin
            isats = ist * m;
            isatd = ist * m;
        end

        // ============ series resistance ===================================
        // Explicit rd/rs, else sheet resistance x squares, else 0 = node
        // collapse (ngspice MOS3setup).
        rdt = rd;
        if (rdt <= 0.0) rdt = rsh * nrd;
        rst = rs;
        if (rst <= 0.0) rst = rsh * nrs;
        if (rdt > 0.0) gdrain = m / rdt; else gdrain = 0.0;
        if (rst > 0.0) gsource = m / rst; else gsource = 0.0;

        // ============ bias and limiting (mos3load.c) ======================
        // As in mos1.va: "fetlimds" on both gate legs + "limvds" emits
        // ngspice's old-vds swap (mos3load.c:349-362). vgd's $limit result is
        // overwritten but the call registers the gate-drain leg. ty is `type`
        // as a real (VerA's frame sign):
        // integer $limit arguments are declined.
        ty     = type;
        vcrits = vt * ln(vt / (1.4142135623730951 * isats));
        vcritd = vt * ln(vt / (1.4142135623730951 * isatd));
        // pnjlimds on both bulk legs: ngspice's rung limits one junction,
        // picked by the LIMITED vds, and moves only the bulk. The argument
        // after the frame sign is the MODEINITJCT seed: vgs = type*tVto,
        // vds = 0, vbs = -1.
        // ponytail: fetlim's threshold is the static tVto, where mos3load.c:339
        // uses the previous load's von; porting the von chain ahead of the
        // limits (as mos1.va does) is the upgrade if a deck needs it.
        vgs = ty * $limit(V(g, si), "fetlimds", ty * (vtox + delvto), ty,
                          ty * vbit + gammax * sqrt(phit));
        vgd = ty * $limit(V(g, di), "fetlimds", ty * (vtox + delvto), ty);
        vds = ty * $limit(V(di, si), "limvds", ty, 0.0);
        vgd = vgs - vds;
        vbs = ty * $limit(V(b, si), "pnjlimds", vt, vcrits, ty, -1.0);
        vbd = ty * $limit(V(b, di), "pnjlimds", vt, vcritd, ty);
        // The channel reads the unlimited body bias (mos3load.c).
        vbsr = type * V(b, si);

        // ============ bulk junctions ======================================
        ibs = jcur(vbs, isats, vt, gmin);
        ibd = jcur(vbd, isatd, vt, gmin);

        // ============ mode swap ===========================================
        // A reversed device runs the same algebra with d/s exchanged.
        if (vds >= 0.0) begin
            mode = 1.0;
            vgsx = vgs;
            vbx  = vbsr;
        end else begin
            mode = -1.0;
            vgsx = vgs - vds;
            vbx  = vbsr - vds;
        end
        vdsx = mode * vds;

        // ============ drain current (level 3) =============================
        // Body-bias square root (Taylor form for forward bias keeps it real).
        if (vbx <= 0.0)
            sarg = sqrt(phit - vbx);
        else
            sarg = sqphit / (1.0 + vbx / (phit + phit));
        phibs = sarg * sarg;

        // Dang short-channel depletion-sharing factor fs.
        if (xjleff > 0.0) begin
            wps  = xdw * sarg;
            wpxj = wps / xj;
            wcxj = 0.0631353 + 0.8013292 * wpxj - 0.01110777 * wpxj * wpxj;
            arga = wcxj + ldxj;
            argc = wpxj / (1.0 + wpxj);
            argb = sqrt(max(1.0 - argc * argc, 0.0));
            fshort = 1.0 - xjleff * (arga * argb - ldxj);
        end else begin
            fshort = 1.0;
        end

        // Body effect + narrow width -> threshold.
        gammas = gammax * fshort;
        fbody  = gammas / (4.0 * sarg) + fnarrow;
        qbonco = gammas * sarg + fnarrow * phibs;
        vbix   = type * vbit - etas * vdsx;
        vth    = vbix + qbonco;

        // Weak-inversion slope from NFS.
        if (nfs > 0.0) begin
            xn  = 1.0 + cscox + qbonco / (2.0 * phibs);
            von = vth + xn * vt;
        end else begin
            xn  = 1.0;
            von = vth;
        end
        vgseff = max(vgsx, von);

        // Mobility: gate-field degradation, then velocity saturation Vdsat.
        onfg  = max(1.0 + theta * (vgseff - vth), 1e-30);
        fgate = 1.0 / onfg;
        avds  = (vgseff - vth) / (1.0 + fbody);
        if (vmax > 0.0) begin
            vdsc  = leff * vmax * onfg / (u0t * 1e-4);
            vdsat = avds + vdsc - sqrt(avds * avds + vdsc * vdsc);
        end else begin
            vdsc  = 0.0;
            vdsat = avds;
        end

        vdson = min(vdsx, max(vdsat, 0.0));
        cdo   = vgseff - vth - 0.5 * (1.0 + fbody) * vdson;
        id    = beta * fgate * cdo * vdson;
        if (vmax > 0.0) begin
            fdrain = 1.0 / (1.0 + vdson / max(vdsc, 1e-30));
            id = id * fdrain;
        end else begin
            fdrain = 1.0;
        end

        // Channel-length modulation (mos3load.c, KAPPA + punch through); needs
        // the depletion coefficient, i.e. NSUB or ALPHA given. With VMAX the
        // saturation field emax sets the offset; the default (badMos3 = 0)
        // delta-L carries the vdsat/8 offset plus a sub-vdsat (vds/vdsat)^4
        // ramp, so delta-L (hence gds) is continuous through vdsat.
        if (alph > 0.0 && kappa > 0.0) begin
            if (vdsx > vdsat) begin
                if (vmax > 0.0) begin
                    // id == cdsat here (vdson was clamped to vdsat).
                    gdsat = max(1e-12, id * (1.0 - fdrain) / max(vdsc, 1e-30));
                    emax  = kappa * id / (leff * gdsat);
                    arga  = 0.5 * emax * alph;
                    delxl = sqrt(arga * arga + kappa * alph * (vdsx - vdsat))
                            - arga;
                end else begin
                    delxl = sqrt(kappa * alph * (vdsx - vdsat + 0.125 * vdsat));
                end
            end else if ((vmax <= 0.0) && (vdsat > 0.0)) begin
                // Sub-vdsat ramp only without VMAX: mos3load.c:728-733 skips
                // it when maxDriftVel > 0 (mos9.va has the same gate).
                delxl = sqrt(0.125 * kappa * alph * vdsat)
                        * pow(vdsx / vdsat, 4.0);
            end else begin
                delxl = 0.0;
            end
            if (delxl > 0.5 * leff)
                delxl = leff - leff * leff / (4.0 * delxl);
            clfact = 1.0 - delxl / leff;
            id = id / clfact;
        end

        // Weak inversion: exponential below von (NFS), hard cutoff without it.
        if (nfs > 0.0)
            id = id * exp(min((vgsx - von) / (xn * vt), 0.0));
        else if (vgsx <= von)
            id = 0.0;

        // ============ junction and gate charges ===========================
        qbs = qdep(vbs, czbs, pbt, mj, fc) + qdep(vbs, czbssw, pbt, mjsw, fc);
        qbd = qdep(vbd, czbd, pbt, mj, fc) + qdep(vbd, czbdsw, pbt, mjsw, fc);

        // Meyer caps, DEVqmeyer in the swapped frame with the channel block's
        // own von/vdsat and Vdsat' = max(Vdsat, MAGIC_VDS = 0.025), which
        // bounds the near-threshold split. DEVqmeyer returns half the
        // non-constant part and the load routine sums two timepoint halves,
        // spelled half + $prev(half) + overlap: ngspice's MODETRAN averaging
        // (the OP/AC value 2*half + overlap comes from $prev's commit at OP
        // exit). Capacitance-based (q advanced as C*dv), not charge
        // conserving, matching ngspice.
        vgst = vgsx - von;
        vdsp = max(vdsat, 0.025);
        if (vgst <= -phit) begin                    // accumulation
            cgbh = 0.5 * coxp * weff * leff * m;
            cgsh = 0.0;
            cgdh = 0.0;
        end else if (vgst <= -0.5 * phit) begin     // depletion
            cgbh = -vgst * coxp * weff * leff * m / (2.0 * phit);
            cgsh = 0.0;
            cgdh = 0.0;
        end else if (vgst <= 0.0) begin             // weak inversion
            // Split by vds like the linear region (devsup.c DEVqmeyer):
            // cgdh = 0 here swapped the caps at the vds = 0 mode flip and
            // Newton 2-cycled there at any dt.
            cgbh = -vgst * coxp * weff * leff * m / (2.0 * phit);
            cgsh = vgst * coxp * weff * leff * m / (1.5 * phit)
                   + coxp * weff * leff * m / 3.0;
            cgdh = 0.0;
            if (vdsx < vdsp) begin
                argb = 2.0 * vdsp - vdsx;
                arga = vdsp - vdsx;
                cgdh = cgsh * (1.0 - vdsp * vdsp / (argb * argb));
                cgsh = cgsh * (1.0 - arga * arga / (argb * argb));
            end
        end else if (vdsp <= vdsx) begin            // saturation
            cgbh = 0.0;
            cgsh = coxp * weff * leff * m / 3.0;
            cgdh = 0.0;
        end else begin                              // linear
            cgbh = 0.0;
            argb = 2.0 * vdsp - vdsx;
            arga = vdsp - vdsx;
            cgdh = (coxp * weff * leff * m / 3.0)
                   * (1.0 - vdsp * vdsp / (argb * argb));
            cgsh = (coxp * weff * leff * m / 3.0)
                   * (1.0 - arga * arga / (argb * argb));
        end
        // Unswap gs/gd BEFORE averaging: ngspice's state slots are
        // device-frame branches, so a mode flip between timepoints still
        // averages gs with gs.
        if (mode > 0.0) begin
            chgs = cgsh;
            chgd = cgdh;
        end else begin
            chgs = cgdh;
            chgd = cgsh;
        end
        // At the operating point $prev is not latched yet, and ngspice's
        // MODETRANOP charge, which the transient's charge history starts
        // from, is (2*half + overlap)*v (mos3load.c).
        // ngspice stamps geq = ag0*C with no dC/dV term (NIintegrate at
        // mos3load.c:1182): vera_nodiff keeps the caps coefficients, so C*ddt(V)
        // linearizes to exactly C.
        (* vera_nodiff *) if (analysis("static")) begin
            capgs = 2.0 * chgs + cgsov;
            capgd = 2.0 * chgd + cgdov;
            capgb = 2.0 * cgbh + cgbov;
        end else begin
            capgs = chgs + $prev(chgs) + cgsov;
            capgd = chgd + $prev(chgd) + cgdov;
            capgb = cgbh + $prev(cgbh) + cgbov;
        end
        // The first Newton iteration of a transient step (mos3load.c:1128-1170).
        // MODEINITPRED extrapolates the gate charges from the last two
        // accepted points. On the host's linear predictor that is the
        // increment since the last accept at that accept's capacitance.
        // MODEINITTRAN, the first step, stamps no gate-cap current or
        // conductance; $abstime > 0 leaves out the t = 0 commit.
        // ngspice's geq keeps the present capacitance, so the extrapolation
        // is a second ddt() site per cap on a frozen copy of the voltage:
        // (pcap - cap)*(V - V_accept) in value, no Jacobian, zero at every
        // accepted point.
        pcapgs = $prev(capgs);
        pcapgd = $prev(capgd);
        pcapgb = $prev(capgb);
        (* vera_nodiff *) begin
            vgsf = V(g, si);
            vgdf = V(g, di);
            vgbf = V(g, b);
        end
        if (analysis("static") || $simparam("iteration") != 1) begin
            pcapgs = capgs;
            pcapgd = capgd;
            pcapgb = capgb;
        end
        @(initial_step("tran")) begin
            if ($abstime > 0.0 && $simparam("iteration") == 1) begin
                capgs = 0.0;
                capgd = 0.0;
                capgb = 0.0;
                pcapgs = 0.0;
                pcapgd = 0.0;
                pcapgb = 0.0;
            end
        end

        // ============ contributions =======================================
        I(di, si) <+ type * m * mode * id;
        I(b, di) <+ type * ibd;
        I(b, si) <+ type * ibs;
        // qbd/qbs join no LTE check: mos3trun.c truncates qgs, qgd, qgb only.
        (* vera_lte = 0 *) I(b, di) <+ type * ddt(qbd);
        (* vera_lte = 0 *) I(b, si) <+ type * ddt(qbs);
        I(g, si) <+ capgs * ddt(V(g, si));
        I(g, di) <+ capgd * ddt(V(g, di));
        I(g, b)  <+ capgb * ddt(V(g, b));
        (* vera_lte = 0 *) I(g, si) <+ (pcapgs - capgs) * ddt(vgsf);
        (* vera_lte = 0 *) I(g, di) <+ (pcapgd - capgd) * ddt(vgdf);
        (* vera_lte = 0 *) I(g, b) <+ (pcapgb - capgb) * ddt(vgbf);
        if (gdrain > 0.0) I(d, di) <+ gdrain * V(d, di);
        else V(d, di) <+ 0.0;
        if (gsource > 0.0) I(s, si) <+ gsource * V(s, si);
        else V(s, si) <+ 0.0;

        // ============ noise (mos3noi.c) ===================================
        // A collapsed RD/RS is a short and has no thermal noise. gm comes from
        // the same AD machinery as the Jacobian.
        if (gdrain > 0.0)
            I(d, di) <+ white_noise(4.0 * 1.38064852e-23 * tk * gdrain, "rd");
        if (gsource > 0.0)
            I(s, si) <+ white_noise(4.0 * 1.38064852e-23 * tk * gsource, "rs");
        // Channel: Sid = (2/3)|gm| (NLEV < 3) or the gdsnoi form (NLEV = 3);
        // flicker per NLEV on mos3noi.c's W - 2*WD and L - 2*LD (#84). The
        // KF*|id|^AF/(W L Cox'^2) form was ngspice's compat-s3 branch only.
        gmch = m * abs(ddx(id, V(g)));
        wn = w - 2.0 * wd;
        ln_ = l - 2.0 * ld;
        if (nlev < 3) sid = 2.0 / 3.0 * gmch;
        else if (vgst > 0.0) begin
            if (vgst <= vdsx) alphan = 0.0;
            else alphan = 1.0 - vdsx / vdsat;
            sid = 2.0 / 3.0 * kpt * m * w / ln_ * vgst * (1.0 + alphan + alphan * alphan) / (1.0 + alphan) * gdsnoi;
        end else sid = 0.0;
        I(di, si) <+ white_noise(4.0 * 1.38064852e-23 * tk * sid, "channel");
        if (nlev == 0)
            fln = kf * m * pow(abs(id), af) / (ln_ * ln_ * coxp);
        else if (nlev == 1)
            fln = kf * m * pow(abs(id), af) / (wn * ln_ * coxp);
        else
            fln = kf * gmch * gmch / (m * wn * ln_ * coxp);
        I(di, si) <+ flicker_noise(fln, (nlev < 2) ? 1.0 : af, "flicker");
    end
endmodule
