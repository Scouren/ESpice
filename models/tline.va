// Ideal lossless transmission line: Branin method of characteristics.
//
// Verilog-A implementation: Omar El-Sawy, University of Waterloo.
// Based on: ngspice T element (tra/traload.c, trasetup.c), Branin's
//   method-of-characteristics line model.
//   ngspice: Copyright Regents of the University of California and others,
//   modified BSD license.
//
// Each port is a Thevenin branch, Z0 in series with the delayed reflected wave
// from the far port:
//
//   v1 - Z0*i1 = v2(t-Td) + Z0*i2(t-Td)
//   v2 - Z0*i2 = v1(t-Td) + Z0*i1(t-Td)
//
// Topology follows traload.c: int1/int2 hold the Thevenin source, G0 = 1/Z0
// sits between pos and int, and I(br) is the port current. At DC the delay
// history is empty, so the transparent-line rows are stamped explicitly under
// analysis("static") (LRM §5.8.1 allows an analysis expression to guard a
// filter function).

`include "constants.vams"
`include "disciplines.vams"

module tline(p1, n1, p2, n2);
    inout p1, n1, p2, n2;
    electrical p1, n1, p2, n2;
    electrical int1, int2;
    branch (int1, n1) br1;
    branch (int2, n2) br2;

    parameter real z0 = 50.0 from (0:inf);   // characteristic impedance [ohm]
    // Delay: TD if given, else NL/F (ngspice T card). A parameter default is
    // evaluated after overrides, so this is the "given" test; LRM §4.5.7
    // requires the absdelay argument to be a plain parameter.
    parameter real f  = 1e9  from (0:inf);   // frequency at which nl is measured [Hz]
    parameter real nl = 0.25 from (0:inf);   // line length in wavelengths at f
    parameter real td = nl / f from (0:inf); // delay [s]

    // ngspice IC=V1,I1,V2,I2: under uic, the delay history at t <= 0
    // (traload.c:61-66, 79-86). KNOWN GAP: declared and read by nothing;
    // the host seeds the absdelay ring from the start vector, and this
    // module cannot tell a uic start from the transient's operating point.
    // So no card reaches them: net_lines.zig addTline refuses a T card's
    // v1, v2, i1, i2 and ic= under uic, drops them without it (as ngspice),
    // and refuses ic_v1..ic_i2 by name (tran/ltra_tran_uic_initial_conditions.sp).
    // They get wired when a uic route lands (a uic bit in the analysis).
    parameter real ic_v1 = 0.0;              // V(p1,n1) at t <= 0 [V]
    parameter real ic_i1 = 0.0;              // I(br1)   at t <= 0 [A]
    parameter real ic_v2 = 0.0;              // V(p2,n2) at t <= 0 [V]
    parameter real ic_i2 = 0.0;              // I(br2)   at t <= 0 [A]

    // Slope-change tolerances for the t+Td breakpoints (ngspice REL/ABS);
    // breakpoints are registered by the host.
    parameter real rel_slope = 1.0 from (0:inf);  // ngspice REL
    parameter real abs_slope = 1.0 from (0:inf);  // ngspice ABS

    real g0, zg;

    analog begin
        g0 = 1.0 / z0;
        // (1 - gmin) on the far-port current keeps the DC rows nonsingular
        // when nothing else pins i_br1 - i_br2 (traload.c MODEDC).
        zg = z0 * (1.0 - $simparam("gmin", 1e-12));

        // An edge launched at t must be resolvable when it lands at t+Td.
        $bound_step(0.25 * td);

        // Thevenin series conductance, pos_k -- int_k.
        I(p1, int1) <+ g0 * V(p1, int1);
        I(p2, int2) <+ g0 * V(p2, int2);

        if (analysis("static")) begin
            // Zero frequency: the line is transparent.
            V(br1) <+ V(p2, n2) + zg * I(br2);
            V(br2) <+ V(p1, n1) + zg * I(br1);
        end else begin
            // I(br) enters the near port, so V(p,n) + z0*I(br) is that port's
            // outgoing wave. vera_interp = 2 reads the history the way
            // traload.c:88-141 does: a 3-point Lagrange fit over the two
            // samples bracketing t-Td and the one before them.
            V(br1) <+ absdelay (* vera_interp = 2 *) (V(p2, n2) + z0 * I(br2), td);
            V(br2) <+ absdelay (* vera_interp = 2 *) (V(p1, n1) + z0 * I(br1), td);
        end
    end
endmodule
