// HFET1: analytic HEMT (ngspice netlist letter Z, `.model <name> NHFET|PHFET
// LEVEL=5`). LEVEL=1 selects MES (Statz), LEVEL=2..4 MESA, LEVEL=6 HFET2
// (inpdomod.c:145-198).
//
// Verilog-A implementation: Omar El-Sawy, University of Waterloo.
// Based on: ngspice hfet1 (hfetload.c, hfettemp.c, hfetsetup.c: hfeta(),
//   leak(), diode()), the Berkeley SPICE3 HFET model (T. Ytterdal).
//   ngspice: Copyright Regents of the University of California and others,
//   modified BSD license.
//
// Structure: §1 (topology + normal/inverse swap), §1.4
// (DIBL V_T,eff, exponential subthreshold with unified n_s, knee shaping,
// dual-exponential gate leakage + GGR), §1.5 (temperature/limiting), §3
// (fet_eval spine). §1.4 defers the HFET1 equations to ngspice, so the algebra
// below is transcribed from hfetload.c/hfettemp.c.
//
// Topology (hfetload.c:443-470 stamp rows): d--RD--dp, s--RS--sp, g--RG--gp;
// gate leakage gp-sp / gp-dp, channel dp-sp. RDI/RSI are not RD/RS: they are
// folded into the channel conductance as `rt` (hfeta()). ngspice's RI/RF gate
// access nodes (s''/d'') are not modelled; with their default RI=RF=0 they
// collapse onto sp/dp, which is where the Meyer caps land here.

`include "constants.vams"
`include "disciplines.vams"

module hfet1(d, g, s);
    inout d, g, s;
    electrical d, g, s;
    electrical dp, sp, gp;                        // behind RD / RS / RG

    branch (d, dp) brd;
    branch (s, sp) brs;
    branch (g, gp) brg;

    // --- instance geometry / temperature ---
    parameter real w     = 20e-6 from (0:inf);    // gate width [m]
    parameter real l     = 1e-6  from (0:inf);    // gate length [m]
    parameter real mult  = 1.0   from (0:inf);    // parallel multiplicity (ngspice
                                                  // *instance* `m`; the model-level
                                                  // `m` below is the knee shape)
    parameter real dtemp = 0.0;                   // instance temp offset [K]
    parameter real temp  = 27.0;                  // explicit instance temp [degC]
                                                  // (hfetparam.c:61-63); wins over
                                                  // dtemp (hfettemp.c:62-68)
    // No model TNOM: ngspice refers every tempco to .options tnom
    // (CKTnomTemp, hfettemp.c:71-73) and 44.2 prints "unrecognized parameter
    // (tnom) - ignored" for one on the card, which a degC card value read
    // here as kelvin would not.

    // --- polarity / gate model selection ---
    parameter integer type    = 1 from [-1:1] exclude 0;  // +1 NHFET, -1 PHFET
    parameter integer gatemod = 0 from [0:1];             // 0 dual-exp leakage,
                                                          // 1 thermionic gate

    // --- channel ---
    parameter real vto     = 0.15;                // threshold [V] (PHFET: -0.15)
    aliasparam vt0 = vto;                    // ngspice hfet.c:46-47 IOPR spelling
    parameter real lambda  = 0.15;                // channel-length modulation [1/V]
    parameter real mu      = 0.4    from (0:inf); // low-field mobility [m^2/Vs]
    parameter real vs      = 1.5e5  from (0:inf); // saturation velocity [m/s]
    parameter real di      = 4e-8   from (0:inf); // barrier thickness [m]
    parameter real deltad  = 4.5e-9 from [0:inf); // 2DEG centroid offset [m]
    parameter real epsi    = 12.244 * 8.85418e-12;         // barrier permittivity [F/m]
    parameter real nmax    = 2e16   from (0:inf); // max sheet density [1/m^2]
    parameter real eta     = 1.28   from (0:inf); // subthreshold ideality (PHFET 1.4)
    parameter real delta   = 3.0;                 // subthreshold smoothing (unitless)
    parameter real gamma   = 3.0    from (0:inf); // power-law clamp exponent
    parameter real m       = 3.0    from (0:inf); // I-V knee shape
    parameter real mc      = 3.0    from (0:inf); // C-V knee shape
    parameter real sigma0  = 0.057;               // DIBL coefficient
    parameter real vsigmat = 0.3;                 // DIBL onset [V]
    parameter real vsigma  = 0.1    from (0:inf); // DIBL onset width [V]
    parameter real p       = 1.0;                 // Cgs/Cgd partition weight (PM)

    // --- second (delta-doped) 2DEG layer: active only when both are given,
    //     which here means both > 0 (hfetload.c:598-601) ---
    parameter real eta2 = 0.0 from [0:inf);       // ideality of layer 2 (ngspice 2)
    parameter real d2   = 0.0 from [0:inf);       // thickness of layer 2 [m]
    parameter real vt2  = -1e30;                  // layer-2 threshold [V]; <=-9e29
                                                  // means "not given" -> VTO

    // --- series parasitics: RD/RS/RG are real external resistors,
    //     RDI/RSI are folded into the channel ---
    parameter real rd  = 0.0 from [0:inf);
    parameter real rs  = 0.0 from [0:inf);
    parameter real rg  = 0.0 from [0:inf);
    parameter real rdi = 0.0 from [0:inf);
    parameter real rsi = 0.0 from [0:inf);

    // --- gate leakage, gatemod = 0 (leak() + GGR) ---
    parameter real js1s = 1.0     from [0:inf);
    parameter real js2s = 1.15e6  from [0:inf);
    parameter real js1d = 1.0     from [0:inf);
    parameter real js2d = 1.15e6  from [0:inf);
    parameter real m1s  = 1.32    from (0:inf);
    parameter real m2s  = 6.9     from (0:inf);
    parameter real m1d  = 1.32    from (0:inf);
    parameter real m2d  = 6.9     from (0:inf);
    parameter real rgs  = 90.0    from [0:inf);   // series R inside leak(), source
    parameter real rgd  = 90.0    from [0:inf);   // series R inside leak(), drain
    parameter real ggr  = 40.0    from [0:inf);
    parameter real del  = 0.04;

    // --- gate leakage, gatemod = 1 (thermionic + self-heating) ---
    parameter real astar  = 4.0e4 from [0:inf);   // Richardson constant [A/m^2K^2]
    parameter real phib   = 0.5;                  // barrier height [eV]; ngspice stores
                                                  // phib*CHARGE in J (hfetmpar.c:188-191)
    parameter real talpha = 1200.0;               // self-heating coefficient [K/V^2]
    parameter real mt1    = 3.5   from (0:inf);
    parameter real mt2    = 9.9   from (0:inf);
    parameter real ck1    = 1.0;
    parameter real ck2    = 0.0;
    parameter real cm1    = 3.0;
    parameter real cm2    = 0.0;
    parameter real cm3    = 0.17;
    parameter real a1     = 0.0;                  // correction-current weights
    parameter real a2     = 0.0;
    parameter real mv1    = 3.0   from (0:inf);

    // --- capacitance ---
    parameter real cds  = 0.0    from [0:inf);
    parameter real eta1 = 2.0    from (0:inf);
    parameter real d1   = 3e-8   from (0:inf);
    parameter real vt1  = -1e30;                  // <=-9e29: "not given" ->
                                                  // VTO + q*NMAX*DI/EPSI

    // --- temperature coefficients (all referred to tnom, hfettemp.c:71-73) ---
    parameter real kvto    = 0.0;
    parameter real kmu     = 0.0;
    parameter real klambda = 0.0;
    parameter real tf      = 27.0;                 // FGDS/DELF reference [degC], read
                                                   // as ngspice reads it (hfetmpar.c:
                                                   // 180-183; its default is the
                                                   // circuit temperature). FGDS/DELF
                                                   // are dead in hfetload.c, so tf
                                                   // is inert
    parameter real gmin = $simparam("gmin") from [0:inf);      // only inside the gate diodes

    // ---- diode(): ngspice hfetload.c:772-798, the exact large-argument
    //      continuation of the ideal diode in normalised form.  This is what
    //      keeps leak() differentiable instead of a hard exp() clamp. ----
    analog function real diode_i;
        input u;
        real u;
        real ex, it, ut, bq, cc;
        begin
            if (u <= -2.303) begin
                ex = exp(u);
                it = ex * (1.0 - ex);
            end else begin
                bq = 0.5 * (u + 2.303);
                it = u + 2.221 * exp((-2.303 - u) / 6.804)
                       - ln(bq + sqrt(bq * bq + 0.25 * 1.685 * 1.685));
            end
            ut = it + ln(it);
            bq = u - ut;
            cc = 1.0 + it;
            diode_i = it * (1.0 + bq / cc + 0.5 * bq * bq / cc / cc / cc);
        end
    endfunction

    // ---- leak(): ngspice hfetload.c:481-522.  The two Schottky exponentials
    //      are in SERIES (harmonic sum of the two branch currents), with a
    //      series resistance rsq and one Newton continuation step around the
    //      operating point (v0, dvdi0).  iseff and the two ln() shifts
    //      (ln1, lne) are parameter-only: the caller computes them once in
    //      the bias-independent prep and passes them in. ----
    analog function real leak;
        input v, vtq, rsq, is1, is2, mm1, mm2, gmn, iseff, ln1, lne;
        real v, vtq, rsq, is1, is2, mm1, mm2, gmn, iseff, ln1, lne;
        real vtt1, vtt2, vteff, i1, i2, ia, dvdi0, v0, unorm;
        begin
            vtt1 = vtq * mm1;
            vtt2 = vtq * mm2;
            if (v > -10.0 * vtt1) begin
                vteff = vtt1 + vtt2;
                if (rsq > 0.0) begin
                    unorm = (v + rsq * is1) / vtt1 + ln1;
                    i1    = vtt1 * diode_i(unorm) / rsq - is1;
                    unorm = (v + rsq * iseff) / vteff + lne;
                    i2    = vteff * diode_i(unorm) / rsq - iseff;
                end else begin
                    // ponytail: the rsq == 0 arm is the only place ngspice uses a
                    // bare exp(); min() keeps it from overflowing to inf (where
                    // the harmonic sum would go NaN).  Default rgs/rgd = 90 takes
                    // the diode_i() path anyway.
                    i1 = is1   * (exp(min(v / vtt1,  80.0)) - 1.0);
                    i2 = iseff * (exp(min(v / vteff, 80.0)) - 1.0);
                end
                if (i1 * i2 != 0.0) ia = 1.0 / (1.0 / i1 + 1.0 / i2);
                else                ia = 0.5 * (i1 + i2);
                dvdi0 = rsq + vtt1 / (ia + is1) + vtt2 / (ia + is2);
                // ponytail: ia > -is1 analytically, so the ln arguments are
                // positive; the floor only stops a stray NR iterate from
                // producing NaN instead of a large finite residual.
                v0 = rsq * ia + vtt1 * ln(max(ia / is1 + 1.0, 1e-300))
                              + vtt2 * ln(max(ia / is2 + 1.0, 1e-300));
                leak = max(-is1, ia + (v - v0) / dvdi0) * 0.99999;
            end else begin
                leak = gmn * v - is1;             // reverse arm: gmin shunt only
            end
        end
    endfunction

    // bias-independent prep (hfettemp.c)
    real tempk, tnom, dtn, vth, etavth, mu_t, vto_t, lambda_t, vt1_i, vt2_i;
    real n0, n02, gchi0, imax, vl, cf, area_half, rt, wl, iso, ggrwl;
    real is1s_a, is2s_a, is1d_a, is2d_a, deltasqr, csat_th;
    real iseff_s, ln1_s, lne_s, iseff_d, ln1_d, lne_d;
    // bias-dependent
    real vgs, vgd, vds, vx, vdsx, inv, igs, igd, arg, earg;
    real sfac, sigma, vgt0, vgt, uu, tt, vgte, xb, rb, nsm, nsc, nsn;
    real delnsmvgt, delnsnsm, delvgtvgs, cc, ns, gchi, gch, gchim, hh, pp;
    real isatm, gg, isat, vsate, ratio, dd, ee, idrain;
    real cg1, cgc, vdse, aa, pfac, capgs, capgd, swp;
    real vkneet, vmax, bb, td, vte_td, hh2, vtn, corr;

    analog begin
        // ==== §1.5 temperature map — hfettemp.c:62-90 =====================
        // Instance temperature tracks .options temp / .temp unless given.
        if ($param_given(temp)) tempk = temp + 273.15;
        else                    tempk = $temperature + dtemp;
        tnom = $simparam("tnom") + 273.15;        // .options tnom [K]
        dtn = tempk - tnom;                       // reference is tnom, NOT tf
        vth = 1.38064852e-23 / 1.6021766208e-19 * tempk;

        mu_t     = mu     - kmu     * dtn;        // hfettemp.c:72, minus sign
        lambda_t = lambda + klambda * dtn;        // hfettemp.c:71, plus sign
        vto_t    = type * vto - kvto * dtn;       // :52 (threshold *= type), :73
        if (vt2 > -9e29) vt2_i = vt2; else vt2_i = type * vto;
        if (vt1 > -9e29) vt1_i = vt1;
        else vt1_i = type * vto + 1.6021766208e-19 * nmax * di / epsi;

        etavth = eta * vth;
        n0     = epsi * eta * vth / (2.0 * 1.6021766208e-19 * (di + deltad));
        if (eta2 > 0.0 && d2 > 0.0)
            n02 = epsi * eta2 * vth / (2.0 * 1.6021766208e-19 * d2);
        else
            n02 = 0.0;
        gchi0 = 1.6021766208e-19 * w * mu_t / l;   // hfettemp.c:80 — no factor 2
        imax  = 1.6021766208e-19 * nmax * vs * w;
        vl    = (vs / mu_t) * l;
        cf    = 0.5 * epsi * w;
        wl    = w * l;
        rt    = rsi + rdi;                        // folded into the channel
        deltasqr = delta * delta;                 // DELTA is dimensionless

        area_half = wl / 2.0;
        is1s_a = js1s  * area_half;
        is2s_a = js2s  * area_half;
        is1d_a = js1d  * area_half;
        is2d_a = js2d  * area_half;
        // leak() invariants, same expressions leak() used to evaluate per call
        iseff_s = 0.0; ln1_s = 0.0; lne_s = 0.0;
        if (is1s_a > 0.0 && is2s_a > 0.0) begin
            iseff_s = is2s_a * pow(is1s_a / is2s_a, m1s / (m1s + m2s));
            if (rgs > 0.0) begin
                ln1_s = ln(rgs * is1s_a / (vth * m1s));
                lne_s = ln(rgs * iseff_s / (vth * m1s + vth * m2s));
            end
        end
        iseff_d = 0.0; ln1_d = 0.0; lne_d = 0.0;
        if (is1d_a > 0.0 && is2d_a > 0.0) begin
            iseff_d = is2d_a * pow(is1d_a / is2d_a, m1d / (m1d + m2d));
            if (rgd > 0.0) begin
                ln1_d = ln(rgd * is1d_a / (vth * m1d));
                lne_d = ln(rgd * iseff_d / (vth * m1d + vth * m2d));
            end
        end
        ggrwl  = ggr   * area_half;
        iso    = astar * area_half;
        csat_th = iso * tempk * tempk
                * exp(-phib * 1.6021766208e-19 / (1.38064852e-23 * tempk));

        // ==== §3 bias ====================================================
        // §1.5 limiting: fetlim on both gate branches (hfetload.c:268). The
        // host owns the algorithm ($limit is the identity inside eval). The
        // MODEINITJCT seed (vgs = vgd = -1) is a solver initial guess, not
        // expressible here.
        vgs = type * $limit(V(gp, sp), "fetlim", vto_t);
        vgd = type * $limit(V(gp, dp), "fetlim", vto_t);
        vds = vgs - vgd;

        // ==== normal/inverse mode (hfetload.c:298-311) ====================
        // hfeta() is always evaluated with |vds| and the upstream gate bias.
        if (vds < 0.0) begin
            inv = 1.0; vx = vgd; vdsx = -vds;
        end else begin
            inv = 0.0; vx = vgs; vdsx = vds;
        end

        // ==== DIBL: the exponent is the gate OVERDRIVE (hfetload.c:591-593) =
        // ponytail: min() only defeats an exp() overflow; where it bites,
        // sigma == 0 and its true derivative is below 1e-34.
        vgt0  = vx - vto_t;
        sfac  = exp(min((vgt0 - vsigmat) / vsigma, 80.0));
        sigma = sigma0 / (1.0 + sfac);
        vgt   = vgt0 + sigma * vdsx;

        // ==== subthreshold smoothing, DELTA dimensionless (:594-596) =======
        uu   = 0.5 * vgt / vth - 1.0;
        tt   = sqrt(deltasqr + uu * uu);
        vgte = vth * (2.0 + uu + tt);

        // ==== unified 2DEG sheet density (:597-601, hfettemp.c:74) =========
        xb = vgt / etavth;
        rb = exp(min(-xb, 80.0));                 // 1/b, floored derivative
        // ponytail: ln(1+0.5*e^x) written asymptotically above x = 80 — same
        // value and same derivative as ngspice, without exp() overflowing.
        if (xb > 80.0) nsm = 2.0 * n0 * (xb - 0.6931471805599453);
        else           nsm = 2.0 * n0 * ln(1.0 + 0.5 * exp(xb));
        delnsmvgt = n0 / etavth / (rb + 0.5);
        if (eta2 > 0.0 && d2 > 0.0) begin
            nsn = nsm;
            nsc = n02 * exp(min((vgt + vto_t - vt2_i) / (eta2 * vth), 80.0));
            nsm = nsn * nsc / (nsn + nsc);
            delnsmvgt = nsc * (nsc * delnsmvgt + nsn * nsn / (eta2 * vth))
                      / ((nsc + nsn) * (nsc + nsn));
        end

        // dVgt/dVgs: sigma is a function of the gate bias, so this is != 1
        // (hfetload.c:645).
        delvgtvgs = 1.0 - vdsx * (sigma0 / vsigma) * sfac
                                / ((1.0 + sfac) * (1.0 + sfac));

        if (nsm < 1.0e-38) begin
            // Cut off exactly as hfetload.c:605-612: no channel current and the
            // bare fringe capacitance, no cgc/cg1 term.
            idrain = 0.0;
            capgs  = cf;
            capgd  = cf;
            vsate  = 0.0;
            vdse   = 0.0;
        end else begin
            cc    = pow(nsm / nmax, gamma);
            ns    = nsm / pow(1.0 + cc, 1.0 / gamma);
            gchi  = gchi0 * ns;
            gch   = gchi / (1.0 + gchi * rt);
            gchim = gchi0 * nsm;

            // velocity-saturation-limited Isat, power-law clamped at Imax
            hh    = sqrt(1.0 + 2.0 * gchim * rsi + vgte * vgte / (vl * vl));
            pp    = 1.0 + gchim * rsi + hh;
            isatm = gchim * vgte / pp;
            gg    = pow(isatm / imax, gamma);
            isat  = isatm / pow(1.0 + gg, 1.0 / gamma);
            vsate = isat / gch;

            // knee shaping + CLM on |vds| (:615-618)
            // ponytail: the 1e-30 floor keeps pow()'s derivative finite at
            // vds == 0 for m < 1; it moves nothing at m >= 1.
            ratio  = max(vdsx / vsate, 1.0e-30);
            dd     = pow(ratio, m);
            ee     = pow(1.0 + dd, 1.0 / m);
            idrain = gch * vdsx * (1.0 + lambda_t * vdsx) / ee;

            // ==== gate charge (:635-637, 645, 656-665) ====================
            delnsnsm = ns / nsm * (1.0 - cc / (1.0 + cc));
            cg1 = 1.0 / (d1 / epsi + eta1 * vth
                       * exp(min(-(vx - vt1_i) / (eta1 * vth), 80.0)));
            cgc = wl * (1.6021766208e-19 * delnsnsm * delnsmvgt * delvgtvgs + cg1);

            vdse = vdsx * pow(1.0 + pow(ratio, mc), -1.0 / mc);
            pfac = p + (1.0 - p) * exp(-vdsx / vsate);
            aa   = (vsate - vdse) / (2.0 * vsate - vdse);
            capgs = cf + (4.0 / 3.0) * cgc * (1.0 - aa * aa) / (1.0 + pfac);
            aa   = vsate / (2.0 * vsate - vdse);
            capgd = cf + (4.0 / 3.0) * pfac * cgc * (1.0 - aa * aa) / (1.0 + pfac);
        end

        // ==== gate currents ==============================================
        if (gatemod == 0) begin
            // Dual exponential in series (leak()) + GGR.  hfetload.c:278-295:
            // if EITHER saturation density is zero the whole diode pair is
            // dropped and only the GGR term survives.
            if (is1s_a > 0.0 && is2s_a > 0.0)
                igs = leak(vgs, vth, rgs, is1s_a, is2s_a, m1s, m2s, gmin, iseff_s, ln1_s, lne_s);
            else
                igs = 0.0;
            arg  = -vgs * del / vth;              // negative exponent, /vth
            earg = exp(min(arg, 80.0));
            igs  = igs + ggrwl * vgs * earg;      // linear-in-v prefactor

            if (is1d_a > 0.0 && is2d_a > 0.0)
                igd = leak(vgd, vth, rgd, is1d_a, is2d_a, m1d, m2d, gmin, iseff_d, ln1_d, lne_d);
            else
                igd = 0.0;
            arg  = -vgd * del / vth;
            earg = exp(min(arg, 80.0));
            igd  = igd + ggrwl * vgd * earg;
        end else begin
            // Thermionic gate with self-heating (hfetload.c:676-765).  Both
            // arms live in the mode frame (vx, vdsx), like ngspice's hfeta().
            // ponytail: max() floors keep vkneet/vmax off zero in cutoff, where
            // vsate == 0 and ngspice divides by zero.
            vkneet = max(ck1 * vsate + ck2, 1.0e-30);
            vmax   = max(cm1 * vsate + cm2, 1.0e-30);
            aa     = pow(max(vdsx / vmax, 1.0e-30), mt2);
            bb     = pow(1.0 + aa, 1.0 / mt2);
            vdse   = vdsx / bb;
            cc     = pow(max(vdse / vkneet, 1.0e-30), mt1);
            dd     = pow(1.0 + cc, 1.0 / mt1);
            td     = tempk + talpha * vdse * vdse / dd;
            vte_td = 1.38064852e-23 / 1.6021766208e-19 * td * m2d;
            hh2    = iso * td * td * exp(-phib * 1.6021766208e-19 / (1.38064852e-23 * td))
                   * exp(min((vx - vdse) / vte_td, 80.0));
            igd    = hh2 - csat_th;

            vtn = vth * m2s;
            if (vx <= -5.0 * vth) igs = gmin * vx - csat_th;
            else igs = csat_th * (exp(min(vx / vtn, 80.0)) - 1.0) + gmin * vx;

            // A1/A2 correction currents fold into the channel (:748-765),
            // still in the mode frame.
            if (a1 != 0.0 || a2 != 0.0) begin
                vmax = max(cm3 * vsate, 1.0e-30);
                aa   = pow(max(vdsx / vmax, 1.0e-30), mv1);
                bb   = pow(1.0 + aa, 1.0 / mv1);
                corr = vdsx / bb;
                idrain = idrain + a1 * ((1.0 + a2 * vgte * corr) * igd - igs);
            end
        end

        // ==== undo the inverse frame (hfetload.c:303-311) =================
        if (inv > 0.5) begin
            idrain = -idrain;
            swp    = capgs;
            capgs  = capgd;
            capgd  = swp;
        end

        // ==== §3 stamps, all scaled by the instance multiplicity ==========
        I(gp, sp) <+ mult * type * igs;
        I(gp, dp) <+ mult * type * igd;
        I(dp, sp) <+ mult * type * idrain;

        // Incremental Meyer capacitances: ngspice integrates dq = C*dv, so the
        // branch current is C*dv/dt — not d(C*v)/dt, which would add a spurious
        // v*dC/dv term (hfetload.c:326-336, 360-369). Its Jacobian entry is
        // geq = ag0*C with no dC/dV either (NIintegrate on capgs, :360-369);
        // vera_nodiff drops the dC/dV forward AD would otherwise stamp.
        (* vera_nodiff *) begin
            capgs = capgs;
            capgd = capgd;
        end
        I(gp, sp) <+ mult * capgs * ddt(V(gp, sp));
        I(gp, dp) <+ mult * capgd * ddt(V(gp, dp));
        // hfettrunc.c truncates qgs and qgd, not qds.
        (* vera_lte = 0 *) I(dp, sp) <+ mult * cds   * ddt(V(dp, sp));

        // Series parasitics; R == 0 stays an exact short, which is ngspice not
        // creating the internal node at all.  m parallel devices divide them.
        V(brd) <+ (rd / mult) * I(brd);
        V(brs) <+ (rs / mult) * I(brs);
        V(brg) <+ (rg / mult) * I(brg);
    end
endmodule
