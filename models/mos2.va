// MOS2: Grove-Frohman analytic bulk-charge MOSFET (netlist letter M, LEVEL=2).
//
// Verilog-A implementation: Omar El-Sawy, University of Waterloo.
// Based on: ngspice mos2 (mos2set.c, mos2temp.c, mos2load.c, mos2noi.c), the
// Berkeley SPICE2/SPICE3 level-2 MOSFET (Grove-Frohman bulk-charge model,
// Baum-Beneking velocity saturation, Meyer gate capacitances).
//   ngspice: Copyright Regents of the University of California and others,
//   modified BSD license.
//
// Laid out section for section like mos1.va; the parameter set and the drain
// current section are what differ.
//
// Channel core, all in the mode-swapped frame:
//   Id = beta*[(vgseff - vbin - eta*vdson/2)*vdson - (2/3)*gamasd*(barg^3 - sarg^3)]
// with gamasd the XJ junction-curvature-corrected body factor, UCRIT/UEXP
// surface-mobility degradation, VMAX velocity-saturation Vdsat (Baum quartic,
// Newton-refined from the Grove-Frohman root), NFS weak inversion and the
// depletion-approximation channel-length modulation with punch-through clamp.
//
// Parameter names/defaults/units are ngspice's (mos2set.c, mos2temp.c).

// One damped-Newton step on the Baum quartic x^4+a1x^3+b1x^2+c1x+d1 = 0.
// Fixed trip count (four steps from the Grove-Frohman root).

`include "constants.vams"
`include "disciplines.vams"

`define BAUMSTEP \
    fx  = (((xr + a1)*xr + b1)*xr + c1)*xr + d1; \
    fpx = ((4.0*xr + 3.0*a1)*xr + 2.0*b1)*xr + c1; \
    xr  = xr - fx*fpx/(fpx*fpx + 1.0e-30);

module mos2(d, g, s, b);
    inout d, g, s, b;
    electrical d, g, s, b;
    electrical di, si;              // internal drain/source behind rd/rs

    // ---- physical constants (ngspice 44 const.h, mos2temp.c EPSSIL) ------
    localparam real kb     = 1.38064852e-23;          // CONSTboltz        [J/K]
    localparam real qe     = 1.6021766208e-19;        // CHARGE              [C]
    localparam real eps_si = 11.7*8.854214871e-12;    // EPSSIL            [F/m]
    localparam real eps_ox = 3.9*8.854214871e-12;     // oxide permittivity [F/m]

    // ---- polarity -------------------------------------------------------
    parameter real type = 1.0 from [-1.0:1.0] exclude 0.0;  // +1 NMOS, -1 PMOS

    // ---- instance ------------------------------------------------------
    parameter real w    = 1.0e-4 from (0:inf);   // channel width           [m]
    parameter real l    = 1.0e-4 from (0:inf);   // channel length          [m]
    parameter real m    = 1.0    from (0:inf);   // device multiplier
    parameter real ad   = 0.0    from [0:inf);   // drain area             [m2]
    parameter real as   = 0.0    from [0:inf);   // source area            [m2]
    parameter real pd   = 0.0    from [0:inf);   // drain perimeter         [m]
    parameter real ps   = 0.0    from [0:inf);   // source perimeter        [m]
    parameter real nrd  = 0.0    from [0:inf);   // drain squares
    parameter real nrs  = 0.0    from [0:inf);   // source squares

    // ---- channel (Grove-Frohman) ---------------------------------------
    parameter real vto    = 0.0;                 // zero-bias threshold      [V]
    aliasparam vt0 = vto;                    // ngspice mos2.c:120 IOPR spelling
    parameter real kp     = 0.0    from [0:inf); // transconductance    [A/V^2]
    parameter real gamma  = 0.0    from [0:inf); // body-effect coeff    [V^0.5]
    parameter real phi    = 0.6    from (0:inf); // surface potential        [V]
    parameter real lambda = 0.0    from [0:inf); // channel-length mod.    [1/V]
    parameter real tox    = 1.0e-7 from (0:inf); // oxide thickness          [m]
    parameter real nsub   = 0.0    from [0:inf); // substrate doping    [cm^-3]
    parameter real nss    = 0.0    from [0:inf); // surface state dens. [cm^-2]
    parameter real nfs    = 0.0    from [0:inf); // fast surface states [cm^-2]
    parameter real neff   = 1.0    from (0:inf); // channel-charge coeff
    parameter real delta  = 0.0    from [0:inf); // narrow-width factor
    parameter real ld     = 0.0    from [0:inf); // lateral diffusion        [m]
    parameter real uo     = 600.0  from (0:inf); // surface mobility  [cm2/V-s]
    aliasparam u0 = uo;
    parameter real ucrit  = 1.0e4  from (0:inf); // mobility crit field  [V/cm]
    parameter real uexp   = 0.0    from [0:inf); // mobility exponent
    parameter real vmax   = 0.0    from [0:inf); // max drift velocity     [m/s]
    parameter real xj     = 0.0    from [0:inf); // junction depth           [m]
    parameter integer tpg = 1;                   // gate material flag

    // ---- series resistance ---------------------------------------------
    parameter real rd  = 0.0 from [0:inf);       // drain resistance      [ohm]
    parameter real rs  = 0.0 from [0:inf);       // source resistance     [ohm]
    parameter real rsh = 0.0 from [0:inf);       // sheet resistance   [ohm/sq]

    // ---- bulk junctions ------------------------------------------------
    parameter real is   = 1.0e-14 from [0:inf);  // sat current             [A]
    parameter real js   = 0.0     from [0:inf);  // sat current density [A/m2]
    parameter real pb   = 0.8     from (0:inf);  // junction potential      [V]
    parameter real cbd  = 0.0     from [0:inf);  // B-D zero-bias cap       [F]
    parameter real cbs  = 0.0     from [0:inf);  // B-S zero-bias cap       [F]
    parameter real cj   = 0.0     from [0:inf);  // bottom cap/area      [F/m2]
    parameter real cjsw = 0.0     from [0:inf);  // sidewall cap/length   [F/m]
    parameter real mj   = 0.5     from (0:1);    // bottom grading
    parameter real mjsw = 0.33    from (0:1);    // sidewall grading
    parameter real fc   = 0.5     from (0:1);    // forward-bias cap coeff

    // ---- gate overlap capacitance --------------------------------------
    parameter real cgso = 0.0 from [0:inf);      // G-S overlap           [F/m]
    parameter real cgdo = 0.0 from [0:inf);      // G-D overlap           [F/m]
    parameter real cgbo = 0.0 from [0:inf);      // G-B overlap           [F/m]

    // ---- noise ---------------------------------------------------------
    parameter real kf   = 0.0 from [0:inf);      // flicker coefficient
    parameter real af   = 1.0 from (0:inf);      // flicker exponent
    parameter integer nlev = 2 from [0:3];       // noise model selection
    parameter real gdsnoi = 1.0 from [0:inf);    // channel shot noise coefficient (NLEV=3)

    // ---- temperature ---------------------------------------------------
    parameter real tnom = $simparam("tnom");     // parameter reference [degC]
    parameter real    temp   = 27.0;                 // instance temperature, overrides $temperature [degC]
    parameter real    dtemp  = 0.0;                  // instance offset from $temperature [K]
    parameter real gmin = $simparam("gmin") from [0:inf);  // junction shunt          [S]

    // bias-independent
    real tk, tnomk, vt, vtnom, fact1, fact2, egfet1, egfet, arg1, argt, ratio;
    real pbfact1, pbfact, phio, pbo, phit, pbt, sqphit, vbit, ist, jst;
    real gmaold, gmanew, cfb, cfsw;
    real phix, vtox, fermis, fermig, wkfng, wkfngs, vfb;
    real coxp, cox, kpt, gammax, nsub_si, xd, leff, weff, beta0;
    real sid, alphan, fln;
    real factor, eta, ucrit_term, gdrain, gsource, isats, isatd;
    real czbd, czbs, czbdsw, czbssw, cgsov, cgdov, cgbov;
    // bias-dependent
    real vgs, vgd, vds, vbs, vbd, vcrits, vcritd, mode, vgsx, vdsx, vbx;
    real sarg, sarg3, phi_vbs, bargv, dsrgdb, dbrgdb, dgddvb, argjs, argjd;
    real vbin, xws, xwd, argss, argsd, gamasd, vth, xn, von, vgseff;
    real udenom, ufact, ueff, gammad, argv, sargv, arg, vdsat, vdsat_gf;
    real xv, v1, v2, a1, b1, c1, d1, xr, fx, fpx, xdv, xlv, xls;
    real dl, clfact, xwb, xld, xleff, beta, vdson, bargd, body, id, gm;
    real ibs, ibd, qbs, qbd;
    real vgst, vdsp, coxm, vddif, vddif1, vddif2;
    real cgs_f, cgd_f, cgb_f, chgs, chgd, chgb, capgs, capgd, capgb;
    real pcapgs, pcapgd, pcapgb, vgsf, vgdf, vgbf;

    // Depletion charge of one junction sidewall/bottom term: the SPICE
    // power law below fc*pb, its linear-capacitance extrapolation above.
    analog function real qdep;
        input v, cz, pbj, mgrad, fcoef;
        real v, cz, pbj, mgrad, fcoef, f1, f2, dv;
        begin
            if (cz <= 0.0) begin
                qdep = 0.0;
            end else if (v < fcoef*pbj) begin
                qdep = pbj*cz*(1.0 - pow(1.0 - v/pbj, 1.0 - mgrad))/(1.0 - mgrad);
            end else begin
                f1 = pbj*(1.0 - pow(1.0 - fcoef, 1.0 - mgrad))/(1.0 - mgrad);
                f2 = pow(1.0 - fcoef, -mgrad);
                dv = v - fcoef*pbj;
                qdep = cz*(f1 + f2*dv + 0.5*f2*mgrad/(pbj*(1.0 - fcoef))*dv*dv);
            end
        end
    endfunction

    analog begin
        // ============ parameter defaulting (mos2temp.c) ====================
        tnomk  = tnom + 273.15;
        vtnom  = kb*tnomk/qe;
        egfet1 = 1.16 - (7.02e-4*tnomk*tnomk)/(tnomk + 1108.0);

        coxp    = eps_ox/tox;                           // eps_ox/tox   [F/m2]
        nsub_si = nsub*1.0e6;                           // cm^-3 -> m^-3
        xd      = (nsub > 0.0) ? sqrt(2.0*eps_si/(qe*nsub_si)) : 0.0;

        // NSUB-driven defaulting of PHI / GAMMA / VTO (mos2temp.c
        // substrateDopingGiven block): surface potential from the doping, then
        // the flat-band voltage from the gate work function (TPG) and the
        // surface-state charge (NSS). "Given" is $param_given, not a value
        // heuristic: an explicit KP=0 / GAMMA=0 card stays 0.
        phix   = phi;
        vtox   = vto;
        gammax = gamma;
        if ($param_given(nsub) && nsub*1.0e6 > 1.45e16) begin
            if (!$param_given(phi))
                phix = max(0.1, 2.0*vtnom*ln(nsub*1.0e6/1.45e16));
            if (!$param_given(gamma))
                gammax = sqrt(2.0*eps_si*qe*nsub_si)/coxp;
            if (!$param_given(vto)) begin
                fermis = type*0.5*phix;
                if (tpg != 0) begin                  // poly gate
                    fermig = tpg*type*0.5*egfet1;
                    wkfng  = 3.25 + 0.5*egfet1 - fermig;
                end else wkfng = 3.2;                // aluminium gate
                wkfngs = wkfng - (3.25 + 0.5*egfet1 + fermis);
                vfb    = wkfngs - qe*nss*1.0e4/coxp;
                vtox   = vfb + type*(gammax*sqrt(phix) + phix);
            end
        end

        // ============ temperature scaling (mos2temp.c) =====================
        // Device temperature: the instance TEMP, else the circuit's plus DTEMP
        // (ngspice CKTtemp + dtemp rule).
        if ($param_given(temp)) tk = temp + 273.15;
        else tk = $temperature + dtemp;
        vt    = kb*tk/qe;
        fact1 = tnomk/300.15;
        fact2 = tk/300.15;
        egfet = 1.16 - (7.02e-4*tk*tk)/(tk + 1108.0);
        arg1  = -egfet1/(2.0*kb*tnomk) + 1.1150877/(2.0*kb*300.15);
        argt  = -egfet/(2.0*kb*tk)    + 1.1150877/(2.0*kb*300.15);
        pbfact1 = -2.0*vtnom*(1.5*ln(fact1) + qe*arg1);
        pbfact  = -2.0*vt   *(1.5*ln(fact2) + qe*argt);

        // KP(T) = KP/r^1.5, mu(T) = UO/r^1.5
        ratio = tk/tnomk;
        kpt   = ($param_given(kp) ? kp : uo*coxp*1.0e-4)/pow(ratio, 1.5);

        phio   = (phix - pbfact1)/fact1;
        pbo    = (pb   - pbfact1)/fact1;
        phit   = max(0.1, fact2*phio + pbfact);
        pbt    = fact2*pbo + pbfact;
        sqphit = sqrt(phit);
        vbit   = vtox - type*(gammax*sqrt(phix)) + 0.5*(egfet1 - egfet)
               + type*0.5*(phit - phix);
        ist    = is*exp(-egfet/vt + egfet1/vtnom);
        jst    = js*exp(-egfet/vt + egfet1/vtnom);

        // two-stage junction-cap temperature factor
        gmaold = (pb - pbo)/pbo;
        gmanew = (pbt - pbo)/pbo;
        cfb    = (1.0 + mj  *(4.0e-4*(tnomk - 300.15) - gmaold));
        cfsw   = (1.0 + mjsw*(4.0e-4*(tnomk - 300.15) - gmaold));
        cfb    = (1.0 + mj  *(4.0e-4*(tk - 300.15) - gmanew))/cfb;
        cfsw   = (1.0 + mjsw*(4.0e-4*(tk - 300.15) - gmanew))/cfsw;

        // ============ geometry, junction sizing ===========================
        leff  = max(l - 2.0*ld, 1.0e-9);
        weff  = w;
        cox   = coxp*weff*leff*m;                       // gate oxide cap  [F]
        beta0 = kpt*m*weff/leff;

        // narrow-width term and its eta / vbin partners (mos2load.c)
        factor = 0.25*`M_PI*eps_si*delta/(coxp*m*weff);
        eta    = 1.0 + factor;
        ucrit_term = ucrit*1.0e2*eps_si/coxp;           // UCRIT*eps_si/Cox'

        // JS is temperature-scaled like IS, and wins only when both areas are
        // given: mos2load.c decides once for the pair, not per junction.
        isats  = ((js > 0.0) && (as > 0.0) && (ad > 0.0)) ? jst*as*m : ist*m;
        isatd  = ((js > 0.0) && (as > 0.0) && (ad > 0.0)) ? jst*ad*m : ist*m;
        czbd   = ((cbd > 0.0) ? cbd : cj*ad)*m*cfb;
        czbs   = ((cbs > 0.0) ? cbs : cj*as)*m*cfb;
        czbdsw = cjsw*pd*m*cfsw;
        czbssw = cjsw*ps*m*cfsw;

        cgsov = cgso*weff*m;
        cgdov = cgdo*weff*m;
        cgbov = cgbo*leff*m;

        // ============ series resistance ===================================
        // RD/RS, else RSH*squares, else 0 = node collapse.
        gdrain  = (rd > 0.0) ? m/rd : ((rsh > 0.0 && nrd > 0.0) ? m/(rsh*nrd) : 0.0);
        gsource = (rs > 0.0) ? m/rs : ((rsh > 0.0 && nrs > 0.0) ? m/(rsh*nrs) : 0.0);

        // ============ bias and limiting (mos2load.c) ======================
        // As in mos1.va: "fetlimds" on both gate legs + "limvds" emits
        // ngspice's swap (fetlim only the leg controlling the channel in the
        // sign of the OLD vds, limvds, derive the other); the trailing `type`
        // is VerA's frame sign. pnjlimds on both bulk legs: ngspice's rung
        // limits one junction, picked by the LIMITED vds, and moves only the
        // bulk. The argument after the frame sign is the MODEINITJCT seed:
        // vgs = type*tVto, vds = 0, vbs = -1.
        // ponytail: fetlim's threshold is the static tVto, where mos2load.c:331
        // uses the previous load's von; porting the von chain ahead of the
        // limits (as mos1.va does) is the upgrade if a mos2 deck needs it.
        vcrits = vt*ln(vt/(1.4142135623730951*isats));
        vcritd = vt*ln(vt/(1.4142135623730951*isatd));
        vgs = type*$limit(V(g, si), "fetlimds", type*vtox, type,
                          type*vbit + gammax*sqphit);
        vgd = type*$limit(V(g, di), "fetlimds", type*vtox, type);
        vds = type*$limit(V(di, si), "limvds", type, 0.0);
        vgd = vgs - vds;
        vbs = type*$limit(V(b, si), "pnjlimds", vt, vcrits, type, -1.0);
        vbd = type*$limit(V(b, di), "pnjlimds", vt, vcritd, type);

        // ============ bulk junctions ======================================
        // limexp is tangent-continued above 80, so no flat-clamp hazard.
        ibs = isats*(limexp(vbs/vt) - 1.0) + gmin*vbs;
        ibd = isatd*(limexp(vbd/vt) - 1.0) + gmin*vbd;

        // ============ mode swap ===========================================
        mode = (vds >= 0.0) ? 1.0 : -1.0;
        vdsx = mode*vds;
        vgsx = (mode > 0.0) ? vgs : vgd;
        vbx  = (mode > 0.0) ? vbs : vbd;

        // ============ drain current (Grove-Frohman) =======================
        // Body terms (mos2load.c "compute some useful quantities"):
        // sarg = sqrt(phi - vbs), bargv = sqrt(phi - vbs + vds), each with the
        // SPICE forward-bias 1/(1 + vb/2phi) guard; phi_vbs is the raw
        // phi - vbs (unguarded in the reference) and feeds vbin, the Vdsat
        // quartic and the drain-side depletion width. dsrgdb / dbrgdb are
        // d(sarg)/dvbs and d(bargv)/dvbs, needed only by the NFS slope factor.
        phi_vbs = phit - vbx;
        if (vbx <= 0.0) begin
            sarg   = sqrt(phi_vbs);
            dsrgdb = -0.5/max(sarg, 1.0e-9);
        end else begin
            sarg   = sqphit/(1.0 + 0.5*vbx/phit);
            dsrgdb = -0.5*sarg*sarg/(phit*sqphit);
        end
        if (vbx - vdsx <= 0.0) begin
            bargv  = sqrt(max(phi_vbs + vdsx, 0.0));
            dbrgdb = -0.5/max(bargv, 1.0e-9);
        end else begin
            bargv  = sqphit/(1.0 + 0.5*(vbx - vdsx)/phit);
            dbrgdb = -0.5*bargv*bargv/(phit*sqphit);
        end
        sarg3 = sarg*sarg*sarg;

        // Threshold: narrow-width vbin plus the XJ-corrected body factor
        // gamasd (short-channel junction-curvature correction).
        vbin = vbit*type + factor*phi_vbs;
        if (xj > 0.0) begin
            xws   = xd*sarg;
            xwd   = xd*bargv;
            argjs = sqrt(1.0 + 2.0*xws/xj);
            argjd = sqrt(1.0 + 2.0*xwd/xj);
            argss = 0.5*xj/leff*(argjs - 1.0);
            argsd = 0.5*xj/leff*(argjd - 1.0);
            dgddvb = -gammax*xd*(dsrgdb/argjs + dbrgdb/argjd)/(2.0*leff);
        end else begin
            argss  = 0.0;
            argsd  = 0.0;
            dgddvb = 0.0;
        end
        gamasd = gammax*(1.0 - argss - argsd);
        vth    = vbin + gamasd*sarg;

        // NFS weak-inversion slope: von is vth raised by vt*xn, and below von
        // the strong-inversion current at von is scaled exponentially. xn's
        // depletion-capacitance term is mos2load.c's cdonco, i.e. the full
        // d(vth)/dvbs: -(gamasd*dsrgdb + dgddvb*sarg) + narrow-width factor.
        if (nfs > 0.0) begin
            xn  = 1.0 + qe*nfs*1.0e4/coxp
                - (gamasd*dsrgdb + dgddvb*sarg) + factor;
            von = vth + vt*xn;
        end else begin
            xn  = 1.0;
            von = vth;
        end
        // mos2load.c's vgsx = max(vgs, von); at vgseff == vth the current
        // vanishes, so this clamp is the cutoff region.
        vgseff = max(vgsx, von);

        // Surface-mobility degradation (UCRIT / UEXP):
        //   mu_eff = mu0*(UCRIT*eps_si/(Cox'*(vgs - von)))^UEXP
        udenom = vgsx - von;
        if ((uexp > 0.0) && (udenom > ucrit_term))
            ufact = pow(ucrit_term/udenom, uexp);
        else
            ufact = 1.0;
        // UO at TNOM, not temperature-scaled: mos2load.c:713 reads the
        // model card's mobility.
        ueff = uo*1.0e-4*ufact;                          // cm2/Vs -> m2/Vs

        // Saturation voltage: Grove-Frohman closed form; with VMAX the Baum
        // velocity-saturation quartic, Newton-refined from it.
        gammad = gamasd/eta;
        argv   = (vgseff - vbin)/eta + phi_vbs;
        if ((gammad > 0.0) && (argv > 0.0)) begin
            arg      = sqrt(1.0 + 4.0*argv/(gammad*gammad));
            vdsat_gf = max((vgseff - vbin)/eta + gammad*gammad*(1.0 - arg)*0.5, 0.0);
        end else begin
            vdsat_gf = max((vgseff - vbin)/eta, 0.0);
        end
        vdsat = vdsat_gf;
        if (vmax > 0.0) begin
            xv = vmax*leff/ueff;
            v1 = (vgseff - vbin)/eta + phi_vbs;
            v2 = phi_vbs;
            a1 = gammad/0.75;
            b1 = -2.0*(v1 + xv);
            c1 = -2.0*gammad*xv;
            d1 = 2.0*v1*(v2 + xv) - v2*v2 - (4.0/3.0)*gammad*sarg3;
            xr = sqrt(max(vdsat_gf + phi_vbs, 0.0));
            `BAUMSTEP
            `BAUMSTEP
            `BAUMSTEP
            `BAUMSTEP
            // Root acceptance as in mos2load.c: only a positive root that
            // actually solves the quartic (|poly4| <= 1e-6) counts; anything
            // else leaves Vdsat at its Grove-Frohman value. Velocity
            // saturation can only lower Vdsat, hence the min.
            fx = (((xr + a1)*xr + b1)*xr + c1)*xr + d1;
            if ((xr > 0.0) && (abs(fx) <= 1.0e-6))
                vdsat = max(min(xr*xr - phi_vbs, vdsat_gf), 0.0);
        end

        // Channel-length modulation from the depletion approximation, with
        // the punch-through clamp (mos2load.c).
        if ((nsub > 0.0) && (lambda == 0.0) && (vmax <= 0.0)) begin
            argv  = 0.25*(vdsx - vdsat);
            sargv = sqrt(1.0 + argv*argv);
            dl    = xd*sqrt(argv + sargv);
        end else if ((nsub > 0.0) && (lambda == 0.0)) begin
            xdv = xd/sqrt(neff);
            xlv = vmax*xdv/(2.0*ueff);
            // Excess is the DRAIN excess above Vdsat (mos2load.c:866-868:
            // argv = lvds - vdsat, clamped at 0); the (vgsx-vbin)/eta - vdsat
            // form at :852 feeds only vqchan/derivative bookkeeping.
            xls = sqrt(xlv*xlv + max(vdsx - vdsat, 0.0));
            dl  = xdv*(xls - xlv);
        end else begin
            dl = lambda*vdsx*leff;
        end
        xwb    = (nsub > 0.0) ? xd*sqrt(max(pbt, 0.1)) : 0.25e-6;
        xld    = leff - xwb;
        xleff  = leff - dl;
        clfact = xleff/leff;
        if (xleff < xwb) begin
            xleff  = xwb/(1.0 + (dl - xld)/xwb);
            clfact = xleff/leff;
        end
        // ponytail: hard floor instead of mos2load.c's derivative-side
        // fixups - clfact -> 0 would make beta infinite.
        clfact = max(clfact, 0.05);
        beta   = beta0*ufact/clfact;

        // The full bulk-charge expression. bargd is barg at min(vds, vdsat)
        // (mos2load.c's barg in the linear region, bsarg in saturation) with
        // the same forward-bias guard as sarg.
        vdson = min(vdsx, vdsat);
        if (vbx - vdson <= 0.0)
            bargd = sqrt(max(phi_vbs + vdson, 0.0));
        else
            bargd = sqphit/(1.0 + 0.5*(vbx - vdson)/phit);
        body = bargd*bargd*bargd - sarg3;
        id   = beta*((vgseff - vbin - eta*vdson*0.5)*vdson - gamasd*body/1.5);
        if ((nfs > 0.0) && (vgsx < von))
            id = id*exp(max((vgsx - von)/(vt*xn), -80.0));

        // ============ junction and gate charges ===========================
        qbs = qdep(vbs, czbs, pbt, mj, fc) + qdep(vbs, czbssw, pbt, mjsw, fc);
        qbd = qdep(vbd, czbd, pbt, mj, fc) + qdep(vbd, czbdsw, pbt, mjsw, fc);

        // Meyer gate capacitances (DEVqmeyer). DEVqmeyer returns half the
        // non-constant part because ngspice averages two timepoints; coxm =
        // 2*Cox feeds the same piecewise, so cg*_f are FULL values and capg*
        // average 0.5*(now + $prev(now)), ngspice's half_now + half_prev
        // MODETRAN sum (the OP/AC value 2*half falls out of $prev's commit at
        // OP exit).
        // ponytail: capacitance-based like ngspice's Meyer, i.e. C*ddt(V), not
        // charge-conserving. Swap to a Ward-Dutton partition only if charge
        // conservation is ever required.
        coxm = 2.0*cox;
        vgst = vgsx - von;
        vdsp = max(vdsat, 0.025);
        if (vgst <= -phit) begin
            cgb_f = coxm*0.5;
            cgs_f = 0.0;
            cgd_f = 0.0;
        end else if (vgst <= -0.5*phit) begin
            cgb_f = -vgst*coxm/(2.0*phit);
            cgs_f = 0.0;
            cgd_f = 0.0;
        end else if (vgst <= 0.0) begin
            // Weak inversion splits by vds like the linear region
            // (devsup.c DEVqmeyer): cgd = 0 here swapped the caps at the
            // vds = 0 mode flip and Newton 2-cycled there at any dt.
            cgb_f = -vgst*coxm/(2.0*phit);
            cgs_f = vgst*coxm/(1.5*phit) + coxm/3.0;
            cgd_f = 0.0;
            if (vdsx < vdsp) begin
                vddif  = 2.0*vdsp - vdsx;
                vddif1 = vdsp - vdsx;
                vddif2 = vddif*vddif;
                cgd_f = cgs_f*(1.0 - vdsp*vdsp/vddif2);
                cgs_f = cgs_f*(1.0 - vddif1*vddif1/vddif2);
            end
        end else if (vdsp <= vdsx) begin
            cgb_f = 0.0;
            cgs_f = coxm/3.0;
            cgd_f = 0.0;
        end else begin
            vddif  = 2.0*vdsp - vdsx;
            vddif1 = vdsp - vdsx;
            vddif2 = vddif*vddif;
            cgb_f = 0.0;
            cgd_f = coxm*(1.0 - vdsp*vdsp/vddif2)/3.0;
            cgs_f = coxm*(1.0 - vddif1*vddif1/vddif2)/3.0;
        end
        chgs = (mode > 0.0) ? cgs_f : cgd_f;             // unswap gs/gd
        chgd = (mode > 0.0) ? cgd_f : cgs_f;
        chgb = cgb_f;
        // At the operating point $prev is not latched yet, and ngspice's
        // MODETRANOP charge, which the transient's charge history starts
        // from, is (2*half + overlap)*v (mos2load.c).
        // ngspice stamps geq = ag0*C with no dC/dV term (NIintegrate at
        // mos2load.c:1304): vera_nodiff keeps the caps coefficients, so C*ddt(V)
        // linearizes to exactly C.
        (* vera_nodiff *) if (analysis("static")) begin
            capgs = cgsov + chgs;
            capgd = cgdov + chgd;
            capgb = cgbov + chgb;
        end else begin
            capgs = cgsov + 0.5*(chgs + $prev(chgs));
            capgd = cgdov + 0.5*(chgd + $prev(chgd));
            capgb = cgbov + 0.5*(chgb + $prev(chgb));
        end
        // The first Newton iteration of a transient step (mos2load.c:1251-1296).
        // MODEINITPRED extrapolates the gate charges from the last two
        // accepted points. On the host's linear predictor that is the
        // increment since the last accept at that accept's capacitance.
        // MODEINITTRAN, the first step, stamps no gate-cap current or
        // conductance; $abstime > 0 leaves out the t = 0 commit.
        // ngspice's geq keeps the present capacitance, so the extrapolation
        // is a second ddt() site per cap on a frozen copy of the voltage:
        // (pcap - cap)*(V - V_accept) in value, no Jacobian, zero at every
        // accepted point.
        pcapgs = $prev(capgs);
        pcapgd = $prev(capgd);
        pcapgb = $prev(capgb);
        (* vera_nodiff *) begin
            vgsf = V(g, si);
            vgdf = V(g, di);
            vgbf = V(g, b);
        end
        if (analysis("static") || $simparam("iteration") != 1) begin
            pcapgs = capgs;
            pcapgd = capgd;
            pcapgb = capgb;
        end
        @(initial_step("tran")) begin
            if ($abstime > 0.0 && $simparam("iteration") == 1) begin
                capgs = 0.0;
                capgd = 0.0;
                capgb = 0.0;
                pcapgs = 0.0;
                pcapgd = 0.0;
                pcapgb = 0.0;
            end
        end

        // ============ contributions =======================================
        I(di, si) <+ type*mode*id;
        I(b, di) <+ type*ibd;
        I(b, si) <+ type*ibs;
        // qbd/qbs join no LTE check: mos2trun.c truncates qgs, qgd, qgb only.
        (* vera_lte = 0 *) I(b, di) <+ type*ddt(qbd);
        (* vera_lte = 0 *) I(b, si) <+ type*ddt(qbs);
        I(g, si) <+ capgs*ddt(V(g, si));
        I(g, di) <+ capgd*ddt(V(g, di));
        I(g, b)  <+ capgb*ddt(V(g, b));
        (* vera_lte = 0 *) I(g, si) <+ (pcapgs - capgs) * ddt(vgsf);
        (* vera_lte = 0 *) I(g, di) <+ (pcapgd - capgd) * ddt(vgdf);
        (* vera_lte = 0 *) I(g, b) <+ (pcapgb - capgb) * ddt(vgbf);
        // RD/RS = 0 collapses d' onto d and s' onto s: the branch becomes a
        // 0 V source, not a large stand-in conductance.
        if (gdrain > 0.0) I(d, di) <+ gdrain*V(d, di);
        else V(d, di) <+ 0.0;
        if (gsource > 0.0) I(s, si) <+ gsource*V(s, si);
        else V(s, si) <+ 0.0;

        // ============ noise (mos2noi.c) ===================================
        // A collapsed RD/RS is a short and has no thermal noise. Channel
        // Sid = (2/3)|gm| (NLEV < 3) or the gdsnoi form (NLEV = 3); flicker
        // per NLEV (mos2noi.c:102-173, #156). gm and id carry m, as MOS2gm and
        // MOS2cd do. The KF*|id|^AF/(W L Cox'^2) form was ngspice's compat-s3
        // branch only.
        if (gdrain > 0.0) I(d, di) <+ white_noise(4.0*kb*tk*gdrain, "rd");
        if (gsource > 0.0) I(s, si) <+ white_noise(4.0*kb*tk*gsource, "rs");
        // gm from the same AD as the Jacobian (noisePsd runs on eval's
        // family, #119). The old beta*vdson left out ufact's and vbin's
        // slope: the thermal floor sat 0.25% off ngspice's.
        gm = abs(ddx(id, V(g)));
        if (nlev < 3) sid = 2.0/3.0*gm;
        else if (vgst > 0.0) begin
            if (vgst <= vdsx) alphan = 0.0;
            else alphan = 1.0 - vdsx/vdsat;
            sid = 2.0/3.0*beta0*vgst*(1.0 + alphan + alphan*alphan)/(1.0 + alphan)*gdsnoi;
        end else sid = 0.0;
        I(di, si) <+ white_noise(4.0*kb*tk*sid, "channel");
        if (nlev == 0)
            fln = kf*m*pow(abs(id)/m, af)/(leff*leff*coxp);
        else if (nlev == 1)
            fln = kf*m*pow(abs(id)/m, af)/(weff*leff*coxp);
        else
            fln = kf*gm*gm/(m*weff*leff*coxp);
        // NLEV 0/1: 1/f; NLEV 2/3: 1/f^AF.
        I(di, si) <+ flicker_noise(fln, (nlev < 2) ? 1.0 : af, "flicker");
    end
endmodule
