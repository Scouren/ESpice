// JFET level 1: Shichman-Hodges quadratic channel with the Sydney University
// "B" doping-tail correction (ngspice J, level 1).
//
// Verilog-A implementation: Omar El-Sawy, University of Waterloo.
// Based on: ngspice J element (jfet/jfetload.c, jfettemp.c, jfetnoi.c), the
//   Shichman-Hodges JFET model as extended in Berkeley SPICE3 with the
//   Sydney University doping-profile parameter B.
//   ngspice: Copyright Regents of the University of California and others,
//   modified BSD license.
//
// Topology (jfetload.c): D--RD--dp, S--RS--sp, gate junction diodes g--dp and
// g--sp, channel current dp--sp, normal/inverse mode swap on sign(vds).
// Evaluation order: bias -> limit -> gate diodes -> mode select -> 3-region
// channel -> gate charges -> stamps -> noise.

`include "constants.vams"
`include "disciplines.vams"

module jfet(d, g, s);
    inout d, g, s;
    electrical d, g, s;
    electrical dp, sp;                          // internal drain/source
    branch (d, dp) brd;
    branch (s, sp) brs;

    // +1 = NJF, -1 = PJF. ngspice carries this in the .model name (njf/pjf).
    parameter integer jtype = 1 from [-1:1] exclude 0;

    // ---- DC channel ---------------------------------------------------------
    parameter real vto    = -2.0;                // V     threshold
    aliasparam vt0 = vto;                    // ngspice jfet.c:53 IOPR spelling
    parameter real beta   = 1.0e-4 from [0:inf); // A/V^2 transconductance
    parameter real lambda = 0.0    from [0:inf); // 1/V   channel-length mod
    parameter real b      = 1.0    from [0:inf); // -     Sydney doping profile
    // ---- gate junctions ------------------------------------------------------
    parameter real is     = 1.0e-14 from [0:inf); // A    gate sat current
    parameter real n      = 1.0     from (0:inf); // -    emission coefficient
    parameter real gmin   = $simparam("gmin") from [0:inf); // S    junction shunt
    // ---- parasitics ----------------------------------------------------------
    parameter real rd     = 0.0 from [0:inf);     // ohm
    parameter real rs     = 0.0 from [0:inf);     // ohm
    // ---- junction capacitance (grading fixed at 1/2) -------------------------
    parameter real cgs    = 0.0 from [0:inf);     // F
    parameter real cgd    = 0.0 from [0:inf);     // F
    parameter real pb     = 1.0 from (0:inf);     // V   gate junction potential
    parameter real fc     = 0.5 from [0:1);       // -   forward-bias cap coeff
    // ---- temperature (jfettemp.c) --------------------------------------------
    parameter real tnom    = $simparam("tnom");   // degC nominal
    // temp = -273.15 is the "not given" sentinel: any card value is an absolute
    // override that ignores dtemp, otherwise JFETtemp = CKTtemp + dtemp
    // (jfettemp.c:83-88).
    parameter real temp    = -273.15;             // degC absolute override
    parameter real dtemp   = 0.0;                 // degC instance offset
    parameter real eg      = 1.11 from (0:inf);   // eV  bandgap for IS(T)
    parameter real xti     = 3.0  from [0:inf);   // -   IS(T) exponent
    parameter real vtotc   = 0.0;                 // V/degC threshold drift
    parameter real tcv     = 0.0;                 // V/degC threshold drift (minus sign)
    parameter real betatce = 0.0;                 // %/degC beta drift
    parameter real bex     = 0.0;                 // -   beta(T) mobility exponent
    // ---- noise (jfetnoi.c) ---------------------------------------------------
    parameter real kf      = 0.0 from [0:inf);    // -   flicker coefficient
    parameter real af      = 1.0 from (0:inf);    // -   flicker exponent
    parameter integer nlev = 0   from [0:3];      // -   channel-thermal form
    parameter real gdsnoi  = 1.0 from [0:inf);    // -   NLEV=3 channel factor
    // ---- geometry ------------------------------------------------------------
    parameter real area    = 1.0 from (0:inf);    // -   area factor
    parameter real m       = 1.0 from (0:inf);    // -   multiplicity

    real tj, tnk, vt, vtnom, fact1, fact2, egfet1, egfet, arg1, argt;
    real pbfact1, pbfact, pbo, pbt, gmaold, gmanew, cjfact, cjfact1, cgs_t, cgd_t;
    real ist, nvt, vcrit, vto_t, beta_t, bfac, scale, fcx, fcpb, f1c, f2, f3;
    real vgs, vgd, vgsc, vgdc, vdsc, mode, vgse, vdse, vgst, betap, apart;
    real ich, gm, id, igs, igd, qgs, qgd, pnch, alpha;

    // Gate junction: I = IS(T)(e^(v/NVt)-1) + gmin*v. Above arg = 80 the
    // exponential is continued by its tangent, keeping dI/dV finite and
    // non-zero so Newton can climb back. Reverse is exact (e^-large -> 0), so
    // jfetload.c's -5*N*Vt linearization is not needed.
    analog function real gatei;
        input v, isat, nvtx, gm0;
        real v, isat, nvtx, gm0, arg;
        begin
            arg = v / nvtx;
            if (arg < 80.0) gatei = isat * (exp(arg) - 1.0) + gm0 * v;
            else gatei = isat * (exp(80.0) * (arg - 79.0) - 1.0) + gm0 * v;
        end
    endfunction

    analog begin
        // ---- bias-independent prep: temperature, geometry, cap constants
        // (jfettemp.c).
        tnk    = tnom + 273.15;
        tj     = temp > -273.0 ? temp + 273.15 : $temperature + dtemp;
        vt     = 1.38064852e-23 / 1.6021766208e-19 * tj;
        vtnom  = 1.38064852e-23 / 1.6021766208e-19 * tnk;
        // IS(T), jfettemp.c: exp((T/tnom-1)*eg/(n*vt)), times (T/tnom)^XTI
        // only when the card gives XTI; the exponent is not divided by n.
        ist    = is * exp((tj / tnk - 1.0) * eg / (n * vt));
        if ($param_given(xti)) ist = ist * pow(tj / tnk, xti);
        // VTO(T)/BETA(T), jfettemp.c: VTOTC and BETATCE win when
        // given; the defaults are the TCV (note the minus sign) and BEX forms.
        if ($param_given(vtotc)) vto_t = vto + vtotc * (tj - tnk);
        else                     vto_t = vto - tcv * (tj - tnk);
        if ($param_given(betatce)) beta_t = beta * pow(1.01, betatce * (tj - tnk));
        else                       beta_t = beta * pow(tj / tnk, bex);
        nvt    = n * vt;
        // pnjlim knee per gate junction; max() keeps IS = 0 (gate diodes
        // disabled) out of ln(0).
        vcrit  = nvt * ln(nvt / (1.4142135623730951 * max(ist, 1.0e-30)));
        // Sydney doping-tail factor, nominal potentials (jfettemp.c JFETbFac).
        // b = 1 => bfac = 0 => classic quadratic Id = betap*vgst^2.
        bfac   = (1.0 - b) / (pb - vto);
        scale  = area * m;

        // Junction-potential and zero-bias-cap temperature maps (jfettemp.c
        // tGatePot / tCGS / tCGD; mos1.va's pbt/cfb with grading 1/2).
        fact1   = tnk / 300.15;
        fact2   = tj / 300.15;
        egfet1  = 1.16 - (7.02e-4 * tnk * tnk) / (tnk + 1108.0);
        egfet   = 1.16 - (7.02e-4 * tj * tj) / (tj + 1108.0);
        arg1    = -egfet1 / (2.0 * 1.38064852e-23 * tnk)
                + 1.1150877 / (2.0 * 1.38064852e-23 * 300.15);
        argt    = -egfet / (2.0 * 1.38064852e-23 * tj)
                + 1.1150877 / (2.0 * 1.38064852e-23 * 300.15);
        pbfact1 = -2.0 * vtnom * (1.5 * ln(fact1) + 1.6021766208e-19 * arg1);
        pbfact  = -2.0 * vt * (1.5 * ln(fact2) + 1.6021766208e-19 * argt);
        pbo     = (pb - pbfact1) / fact1;
        pbt     = fact2 * pbo + pbfact;
        gmaold  = (pb - pbo) / pbo;
        gmanew  = (pbt - pbo) / pbo;
        cjfact  = 1.0 + 0.5 * (4.0e-4 * (tnk - 300.15) - gmaold);
        cjfact1 = 1.0 + 0.5 * (4.0e-4 * (tj - 300.15) - gmanew);
        cgs_t   = cgs * cjfact1 / cjfact;
        cgd_t   = cgd * cjfact1 / cjfact;

        // Depletion-cap forward extension, grading 1/2, on the
        // temperature-shifted potential. FC is clamped at 0.95 as in
        // jfettemp.c: above that f2 = (1-FC)^1.5 collapses.
        fcx    = min(fc, 0.95);
        fcpb   = fcx * pbt;
        f1c    = 2.0 * pbt * (1.0 - sqrt(1.0 - fcx));
        f2     = pow(1.0 - fcx, 1.5);
        f3     = 1.0 - 1.5 * fcx;

        // ---- bias + limiting. jfetload.c runs pnjlim then fetlim on vgs
        // and vgd and takes vds = vgs - vgd, with no limvds (which clamps a
        // negative vds even at the fixed point, #49). One $limit cannot chain
        // two algorithms, so the channel takes fetlim and the junctions
        // pnjlim, each returning its probe at convergence. $limit hands the
        // algorithm to the host and returns the probe unchanged if the host
        // declines. MODEINITJCT's vgs = -1 / OFF seed has no Verilog-A
        // spelling; it belongs to the host's limiter.
        vgsc = jtype * $limit(V(g, sp), "fetlim", vto_t);
        vgdc = jtype * $limit(V(g, dp), "fetlim", vto_t);
        vdsc = vgsc - vgdc;
        vgs  = jtype * $limit(V(g, sp), "pnjlim", nvt, vcrit);
        vgd  = jtype * $limit(V(g, dp), "pnjlim", nvt, vcrit);

        // ---- gate junctions, both sides
        igs = gatei(vgs, ist, nvt, gmin);
        igd = gatei(vgd, ist, nvt, gmin);

        // ---- mode select on sign(vds): swap vgs <-> vgd, work with |vds|
        if (vdsc >= 0.0) begin
            mode = 1.0;
            vgse = vgsc;
        end else begin
            mode = -1.0;
            vgse = vgdc;
        end
        vdse = mode * vdsc;

        // ---- channel, 3 regions. Clamping vgst at 0 makes cutoff fall out
        // of either branch (both are 0 at vgst = 0).
        vgst = vgse - vto_t;
        if (vgst < 0.0) vgst = 0.0;
        betap = beta_t * (1.0 + lambda * vdse);
        if (vdse >= vgst) begin
            // saturation: Id = betap*vgst^2*(B + vgst*Bfac)
            ich = betap * vgst * vgst * (b + vgst * bfac);
            gm  = betap * vgst * (2.0 * b + 3.0 * vgst * bfac);
        end else begin
            // linear: cpart = vds*(vds*(Bfac*vds - B) + vgst*apart)
            apart = 2.0 * b + 3.0 * bfac * (vgst - vdse);
            ich = betap * vdse * (vdse * (bfac * vdse - b) + vgst * apart);
            gm  = betap * vdse * (2.0 * b + 3.0 * bfac * (2.0 * vgst - vdse));
        end
        // Per-device current (area-scaled); m multiplies at the stamp, so the
        // noise PSDs use ngspice's per-device I_D/g_m.
        id = mode * ich * area;

        // ---- gate depletion charges on the pnjlim'd biases, no mode swap,
        // FC quadratic extension above fc*pbt
        if (vgs < fcpb)
            qgs = 2.0 * cgs_t * pbt * (1.0 - sqrt(1.0 - vgs / pbt));
        else
            qgs = cgs_t * (f1c + (f3 * (vgs - fcpb) + 0.25 * (vgs * vgs - fcpb * fcpb) / pbt) / f2);

        if (vgd < fcpb)
            qgd = 2.0 * cgd_t * pbt * (1.0 - sqrt(1.0 - vgd / pbt));
        else
            qgd = cgd_t * (f1c + (f3 * (vgd - fcpb) + 0.25 * (vgd * vgd - fcpb * fcpb) / pbt) / f2);

        // ---- stamps (jfetload.c: ggs/ggd on the junctions, gm/gds on the
        // channel with the xnrm/xrev swap folded into `mode`)
        I(g, sp) <+ jtype * scale * igs + ddt(jtype * scale * qgs);
        I(g, dp) <+ jtype * scale * igd + ddt(jtype * scale * qgd);
        I(dp, sp) <+ jtype * m * id;

        // ---- series RD/RS. rd = 0 is ngspice's node collapse (JFETsetup),
        // here a switch branch lowered to a real short. Thermal noise
        // 4kT*g*A*m on the conducting branch (jfetnoi.c RD/RS rows).
        if (rd > 0.0)
            I(brd) <+ scale * V(brd) / rd
                    + white_noise(4.0 * 1.38064852e-23 * tj * scale / rd, "rd");
        else V(brd) <+ 0.0;
        if (rs > 0.0)
            I(brs) <+ scale * V(brs) / rs
                    + white_noise(4.0 * 1.38064852e-23 * tj * scale / rs, "rs");
        else V(brs) <+ 0.0;

        // ---- channel noise (jfetnoi.c): NLEV<3 is 4kT*(2/3)|gm|, NLEV=3 the
        // alpha-weighted form. gm/vgst/vdse are the mode-frame values.
        if (nlev < 3) pnch = 2.0 / 3.0 * abs(gm) * area;
        else if (vgst > 0.0) begin
            alpha = max(0.0, 1.0 - vdse / vgst);
            pnch = 2.0 / 3.0 * beta_t * area * vgst
                 * (1.0 + alpha + alpha * alpha) / (1.0 + alpha) * gdsnoi;
        end else pnch = 0.0;
        I(dp, sp) <+ white_noise(4.0 * 1.38064852e-23 * tj * pnch * m, "channel");
        if (kf > 0.0)
            I(dp, sp) <+ flicker_noise(m * kf * pow(abs(id), af), 1.0, "flicker");
    end
endmodule
