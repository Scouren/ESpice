// MOS6: Sakurai-Newton n-th power law MOSFET (netlist letter M, LEVEL=6).
//
// Verilog-A implementation: Omar El-Sawy, University of Waterloo.
// Based on: ngspice mos6 (mos6set.c, mos6temp.c, mos6load.c), the SPICE3
// level-6 model after T. Sakurai and A. R. Newton's n-th power law MOSFET,
// on the mos1 chassis (mos1temp.c, mos1noi.c).
//   ngspice: Copyright Regents of the University of California and others,
//   modified BSD license.
//
// Laid out section for section like mos1.va; only the parameter set and the
// drain-current block differ. Channel (mos6load.c): power-law Vdsat/Idsat,
// the (2-u)u parabolic linear blend, lambda = lamda0 - lamda1*vb. Voltage
// limiting (fetlim/limvds/pnjlim) is spelled with $limit: it is the identity
// inside eval, and VerA's contract `limit`/`seed` hooks hand the host the
// clamps to run between the linear solve and the next eval.

`include "constants.vams"
`include "disciplines.vams"

module mos6(d, g, s, b);
    inout d, g, s, b;
    electrical d, g, s, b;
    electrical di, si;              // internal drain/source behind rd/rs

    // ---- polarity ---------------------------------------------------------
    parameter integer type  = 1 from [-1:1] exclude 0;  // +1 NMOS, -1 PMOS

    // ---- channel (Sakurai-Newton), ngspice MOS6 names/defaults -------------
    parameter real    vto   = 0.0;                      // zero-bias threshold [V]
    aliasparam vt0 = vto;                    // ngspice mos6.c:116 IOPR spelling
    // KV = 0 is legal in ngspice (vdsat collapses to 0 => always the saturation
    // expression); mos6set.c range-checks nothing but PHI > 0.
    parameter real    kv      = 2.0 from [0:inf);   // Vdsat coefficient [V^(1-nv)]
    parameter real    nv      = 0.5;                // Vdsat exponent
    parameter real    kc      = 5e-5 from [0:inf);  // Idsat coefficient [A/V^nc]
    parameter real    nc      = 1.0;                // Idsat exponent
    parameter real    u0      = 600.0;              // mobility, for the KC default [cm^2/Vs]
    aliasparam uo = u0;
    parameter real    nsub    = 0.0 from [0:inf);   // substrate doping [cm^-3]
    parameter real    nss     = 0.0 from [0:inf);   // surface states [cm^-2]
    parameter real    tpg     = 1.0 from [-1:1];    // gate: +1 opp, -1 same, 0 Al
    parameter real    gamma   = 0.0 from [0:inf);   // body effect [sqrt(V)]
    parameter real    gamma1  = 0.0;                // linear body term [1/V]
    parameter real    sigma   = 0.0;                // DIBL
    parameter real    phi     = 0.6 from (0:inf);   // surface potential [V]
    parameter real    lambda  = 0.0;                // channel-length modulation [1/V]
    parameter real    lambda0 = 0.0;                // CLM, defaults to lambda [1/V]
    parameter real    lambda1 = 0.0;                // CLM body coefficient [1/V^2]

    // ---- series resistance ------------------------------------------------
    parameter real    rd  = 0.0 from [0:inf);  // drain resistance, 0 => d' collapses onto d [ohm]
    parameter real    rs  = 0.0 from [0:inf);  // source resistance [ohm]
    parameter real    rsh = 0.0 from [0:inf);  // sheet resistance [ohm/square]
    parameter real    nrd = 1.0 from [0:inf);  // drain squares (0/absent => 1 square)
    parameter real    nrs = 1.0 from [0:inf);  // source squares

    // ---- bulk junctions ---------------------------------------------------
    parameter real    is   = 1e-14 from [0:inf);  // saturation current [A]
    parameter real    js   = 0.0 from [0:inf);    // saturation current density [A/m^2]
    parameter real    pb   = 0.8 from (0:inf);    // junction potential [V]
    parameter real    cbd  = 0.0 from [0:inf);    // b-d zero-bias cap [F]
    parameter real    cbs  = 0.0 from [0:inf);    // b-s zero-bias cap [F]
    parameter real    cj   = 0.0 from [0:inf);    // bottom cap [F/m^2]
    parameter real    cjsw = 0.0 from [0:inf);    // sidewall cap [F/m]
    // MJ/MJSW = 0 is legal (constant sarg); only 1.0 must go, qdep / f4 divide
    // by (1 - m).
    parameter real    mj   = 0.5 from [0:1);      // bottom grading
    parameter real    mjsw = 0.5 from [0:1);      // sidewall grading
    parameter real    fc   = 0.5 from (0:1);      // forward-bias cap coefficient
    parameter real    gmin = 1e-12 from [0:inf);  // junction conductance floor [S]

    // ---- gate overlap capacitance, oxide, geometry, temperature -------------
    parameter real    tox  = 0.0 from [0:inf);                         // oxide thickness [m]
    parameter real    cgso = 0.0 from [0:inf);                         // gate-source overlap [F/m]
    parameter real    cgdo = 0.0 from [0:inf);                         // gate-drain overlap [F/m]
    parameter real    cgbo = 0.0 from [0:inf);                         // gate-bulk overlap [F/m]
    parameter real    ld   = 0.0 from [0:inf);                         // lateral diffusion [m]
    parameter real    tnom = $simparam("tnom");     // nominal temperature [degC]
    parameter real    temp   = 27.0;                 // instance temperature, overrides $temperature [degC]
    parameter real    dtemp  = 0.0;                  // instance offset from $temperature [K]

    // ---- noise ------------------------------------------------------------
    parameter real    kf = 0.0 from [0:inf);  // flicker coefficient
    parameter real    af = 1.0 from (0:inf);  // flicker exponent

    // ---- instance ---------------------------------------------------------
    // SPICE DEFW/DEFL (CKTdefaultMosW/L), not 1 um.
    parameter real    w  = 1e-4 from (0:inf);  // channel width [m]
    parameter real    l  = 1e-4 from (0:inf);  // channel length [m]
    parameter real    m  = 1.0 from (0:inf);   // parallel multiplier
    parameter real    ad = 0.0 from [0:inf);   // drain area [m^2]
    parameter real    as = 0.0 from [0:inf);   // source area [m^2]
    parameter real    pd = 0.0 from [0:inf);   // drain perimeter [m]
    parameter real    ps = 0.0 from [0:inf);   // source perimeter [m]

    // bias-independent
    real ty, coxp, tnomk, vtnom, egnom, kcx, phix, gammax, vtox;
    real fermis, fermig, wkfng, wkfngs, vfb;
    real tk, vt, eg, fact1, fact2, arg1, argt, pbfact1, pbfactt;
    real phio, phit, sqphi, vbit, pbo, pbt, gmaold, gmanew, capf, capfsw, ist;
    real leff, weff, cox, coxn, isats, isatd, czbs, czbd, czbssw, czbdsw;
    real betac, lam0, sqd, sqs, gdrain, gsource;
    // bias-dependent
    real vcrits, vcritd, vgs, vds, vbs, vbd, vgd, ibs, ibd;
    real mode, vgsx, vbx, vdsx, sbody, vonp, von, vgst, lvgon, vdsat, vdsatm;
    real idsat, lam, clm, u, fu, id, gmch, qbs, qbd;
    real cgsm, cgdm, cgbm, cbase, vdd, vdd1, chgs, chgd, capgs, capgd, capgb;
    real pcapgs, pcapgd, pcapgb, vgsf, vgdf, vgbf;

    // Bulk junction diode (both junctions, same law). The exponent is
    // tangent-continued above 80*vtx: pnjlim keeps Newton iterates below it,
    // but LTE probes and sweep warm starts evaluate unlimited, and a flat
    // clamp there would zero the restoring slope.
    analog function real jcur;
        input v, isat, vtx, gm;
        real v, isat, vtx, gm;
        real u;
        begin
            if (v > -3.0 * vtx) begin
                u = min(v / vtx, 80.0);
                jcur = isat * (exp(u) * (1.0 + (v / vtx - u)) - 1.0) + gm * v;
            end else jcur = gm * v - isat;
        end
    endfunction

    // Junction depletion charge for one plate: the reverse-bias closed form
    // below fc*pj, and above it the linearization C = f2 + f3*v, derived from
    // the same closed form so C and Q match value and slope at v = fc*pj.
    analog function real qdep;
        input v, cz, pj, mg, fcc;
        real v, cz, pj, mg, fcc;
        real k1, v0, c0, cp, q0, dv;
        begin
            k1 = cz * pj / (1.0 - mg);
            v0 = fcc * pj;
            // mos6load.c:581,640 guard: every term below carries `cz`, so zero
            // capacitance means zero charge without two `pow` per junction.
            if (cz == 0.0) qdep = 0.0;
            else if (v < v0) begin
                qdep = k1 * (1.0 - pow(1.0 - v / pj, 1.0 - mg));
            end else begin
                c0 = cz * pow(1.0 - fcc, -mg);
                cp = c0 * mg / (pj * (1.0 - fcc));
                q0 = k1 * (1.0 - pow(1.0 - fcc, 1.0 - mg));
                dv = v - v0;
                qdep = q0 + c0 * dv + 0.5 * cp * dv * dv;
            end
        end
    endfunction

    analog begin
        // `type` is an integer card value; $limit takes real arguments.
        ty = type;

        // ============ parameter defaulting (mos6temp.c, MOS1's rules) ======
        // "Given" is $param_given, not a value test: every default here (KC,
        // PHI, GAMMA, VTO) is also a legal user value. TOX not given => no
        // intrinsic Meyer caps, as in ngspice (oxideCapFactor stays 0).
        if (tox > 0.0) coxp = 3.9 * 8.854214871e-12 / tox;
        else coxp = 0.0;
        tnomk = tnom + 273.15;
        vtnom = tnomk * (1.38064852e-23 / 1.6021766208e-19);
        egnom = 1.16 - 7.02e-4 * tnomk * tnomk / (tnomk + 1108.0);

        phix   = phi;
        gammax = gamma;
        vtox   = vto;
        if ($param_given(nsub) && nsub * 1e6 > 1.45e16) begin
            if (!$param_given(phi)) phix = max(0.1, 2.0 * vtnom * ln(nsub * 1e6 / 1.45e16));
            if (coxp > 0.0) begin   // both remaining overrides divide by Cox'
                if (!$param_given(gamma))
                    gammax = sqrt(2.0 * 11.7 * 8.854214871e-12
                                  * 1.6021766208e-19 * nsub * 1e6) / coxp;
                if (!$param_given(vto)) begin
                    fermis = ty * 0.5 * phix;
                    if (tpg != 0.0) begin
                        fermig = tpg * ty * 0.5 * egnom;
                        wkfng  = 3.25 + 0.5 * egnom - fermig;
                    end else wkfng = 3.2;
                    wkfngs = wkfng - (3.25 + 0.5 * egnom + fermis);
                    vfb    = wkfngs - nss * 1e4 * 1.6021766208e-19 / coxp;
                    vtox   = vfb + ty * (gammax * sqrt(phix) + phix);
                end
            end
        end
        // KC from TOX/U0 (note the extra 0.5 relative to MOS1's KP rule), only
        // when TOX is given: without it KC keeps its 5e-5 default
        // (mos6set.c:48, mos6temp.c:60-70, #158).
        if ($param_given(kc) || coxp == 0.0) kcx = kc;
        else kcx = 0.5 * u0 * coxp * 1e-4;

        // ============ temperature scaling (mos1temp.c) =====================
        // Identity at T = TNOM.
        // Device temperature: the instance TEMP, else the circuit's plus DTEMP
        // (ngspice CKTtemp + dtemp rule).
        if ($param_given(temp)) tk = temp + 273.15;
        else tk = $temperature + dtemp;
        vt    = tk * (1.38064852e-23 / 1.6021766208e-19);
        eg    = 1.16 - 7.02e-4 * tk * tk / (tk + 1108.0);
        fact1 = tnomk / 300.15;
        fact2 = tk / 300.15;
        // arg is ngspice's literal 1/Joule form; the q factor below converts it,
        // so it must NOT already be divided by q.
        arg1    = -egnom / (2.0 * 1.38064852e-23 * tnomk)
                  + 1.1150877 / (2.0 * 1.38064852e-23 * 300.15);
        argt    = -eg / (2.0 * 1.38064852e-23 * tk)
                  + 1.1150877 / (2.0 * 1.38064852e-23 * 300.15);
        pbfact1 = -2.0 * vtnom * (1.5 * ln(fact1) + 1.6021766208e-19 * arg1);
        pbfactt = -2.0 * vt * (1.5 * ln(fact2) + 1.6021766208e-19 * argt);

        // Surface potential and built-in voltage at T.
        phio  = (phix - pbfact1) / fact1;
        phit  = max(fact2 * phio + pbfactt, 1e-6);
        sqphi = sqrt(phit);
        vbit  = vtox - ty * gammax * sqrt(phix)
                + 0.5 * (egnom - eg) + ty * 0.5 * (phit - phix);

        // Junction potential at T + the two-stage depletion-cap factor.
        pbo    = (pb - pbfact1) / fact1;
        pbt    = max(fact2 * pbo + pbfactt, 1e-6);
        gmaold = (pb - pbo) / pbo;
        gmanew = (pbt - pbo) / pbo;
        capf   = (1.0 + mj * (4e-4 * (tk - 300.15) - gmanew))
                 / (1.0 + mj * (4e-4 * (tnomk - 300.15) - gmaold));
        capfsw = (1.0 + mjsw * (4e-4 * (tk - 300.15) - gmanew))
                 / (1.0 + mjsw * (4e-4 * (tnomk - 300.15) - gmaold));

        // Saturation-current temperature factor.
        ist = exp(-eg / vt + egnom / vtnom);

        // ============ geometry, junction sizing ===========================
        leff = max(l - 2.0 * ld, 1e-9);
        weff = w;
        cox  = coxp * weff * leff * m;
        // Flicker noise uses mos1noi.c's nominal TOX = 1e-7 when Cox' is 0.
        if (coxp > 0.0) coxn = coxp;
        else coxn = 3.9 * 8.854214871e-12 / 1e-7;

        // JS wins only when BOTH areas are given: ngspice decides once for the
        // pair (mos6load.c:127-138), never mixing IS on one junction with JS*A
        // on the other.
        if (js > 0.0 && ad > 0.0 && as > 0.0) begin
            isats = js * as * m * ist;
            isatd = js * ad * m * ist;
        end else begin
            isats = is * m * ist;
            isatd = is * m * ist;
        end

        if (cbs > 0.0) czbs = cbs * m * capf;
        else czbs = cj * as * m * capf;
        if (cbd > 0.0) czbd = cbd * m * capf;
        else czbd = cj * ad * m * capf;
        // Written as an if (a phi) rather than a plain product: qdep's
        // `cz == 0.0` guard is a branch condition, and VerA re-expands a
        // straight-line parameter expression inline at a condition instead of
        // reading the precomputed slot. A phi is materialised, so both arms
        // hoist. CJSW is `from [0:inf)`, so the else arm equals the product.
        if (cjsw > 0.0) czbssw = cjsw * ps * m * capfsw; else czbssw = 0.0;
        if (cjsw > 0.0) czbdsw = cjsw * pd * m * capfsw; else czbdsw = 0.0;

        // Channel prefactor: betac = KC * W * m / Leff, KC temperature-scaled
        // like MOS1's KP: KP(T) = KP / (T/Tnom)^1.5.
        betac = kcx * weff * m / (leff * pow(tk / tnomk, 1.5));

        // lamda0 defaults to LAMBDA when not given (mos6set.c); a given 0 stays.
        if ($param_given(lambda0)) lam0 = lambda0;
        else lam0 = lambda;

        // ============ series resistance ===================================
        // RD/RS, else RSH*squares, else node collapse. Squares default to 1
        // whenever RSH is given (mos6temp.c:294-327), so `.model ... RSH=20`
        // alone still produces the series resistance.
        if (nrd > 0.0) sqd = nrd; else sqd = 1.0;
        if (nrs > 0.0) sqs = nrs; else sqs = 1.0;
        if (rd > 0.0) gdrain = m / rd;
        else if (rsh > 0.0) gdrain = m / (rsh * sqd);
        else gdrain = 0.0;
        if (rs > 0.0) gsource = m / rs;
        else if (rsh > 0.0) gsource = m / (rsh * sqs);
        else gsource = 0.0;

        // ============ bias and limiting (mos6load.c) ======================
        // As in mos1.va: "fetlimds" on both gate legs + "limvds" emits
        // ngspice's old-vds swap (mos6load.c:353-366). vgd's $limit result is
        // overwritten but the call registers the gate-drain leg. Trailing `ty`
        // = VerA frame sign (PMOS limits ty*v). pnjlimds on both bulk legs:
        // ngspice's rung limits one junction, picked by the LIMITED vds, and
        // moves only the bulk. The argument after the frame sign is the
        // MODEINITJCT seed: vgs = type*tVto, vds = 0, vbs = -1.
        // fetlim's threshold is the von the previous load stored (:343, :550),
        // the formula at :483 below; VerA evaluates a solve-dependent limiter
        // argument at that iterate.
        vcrits = vt * ln(vt / (1.4142135623730951 * isats));
        vcritd = vt * ln(vt / (1.4142135623730951 * isatd));
        vdsx = ty * V(di, si);
        if (vdsx >= 0.0) vbx = ty * V(b, si);
        else begin
            vbx  = ty * V(b, di);
            vdsx = -vdsx;
        end
        if (vbx <= 0.0) sbody = sqrt(max(phit - vbx, 0.0));
        else sbody = max(0.0, sqphi - vbx / (2.0 * sqphi));
        vonp = ty * vbit + gammax * sbody - gamma1 * vbx - sigma * vdsx;
        vgs = ty * $limit(V(g, si), "fetlimds", vonp, ty, ty * vbit + gammax * sqphi);
        vgd = ty * $limit(V(g, di), "fetlimds", vonp, ty);
        vds = ty * $limit(V(di, si), "limvds", ty, 0.0);
        vgd = vgs - vds;
        vbs = ty * $limit(V(b, si), "pnjlimds", vt, vcrits, ty, -1.0);
        vbd = ty * $limit(V(b, di), "pnjlimds", vt, vcritd, ty);

        // ============ bulk junctions ======================================
        ibs = jcur(vbs, isats, vt, gmin);
        ibd = jcur(vbd, isatd, vt, gmin);

        // ============ mode swap ===========================================
        if (vds >= 0.0) begin
            mode = 1.0;
            vgsx = vgs;
            vbx  = vbs;
            vdsx = vds;
        end else begin
            mode = -1.0;
            vgsx = vgs - vds;
            vbx  = vbd;
            vdsx = -vds;
        end

        // ============ drain current (Sakurai-Newton, mos6load.c) ==========
        // Body term with the MOS1 Taylor guard (keeps sbody >= 0 for vbx > 0).
        if (vbx <= 0.0) sbody = sqrt(max(phit - vbx, 0.0));
        else sbody = max(0.0, sqphi - vbx / (2.0 * sqphi));

        von  = ty * vbit + gammax * sbody - gamma1 * vbx - sigma * vdsx;
        vgst = vgsx - von;

        // Power-law Vdsat. In cutoff the base is the 1e-30 floor, so vdsat is
        // a parameter-only constant that hoists to precompute; the Meyer block
        // still reads it through max(vdsat, 0.025). ngspice skips it in cutoff
        // too (mos6load.c:493).
        // One ln is shared by both power laws, as mos6load.c:502-505 spells it
        // (`sarg1 = log(vgon); vdsat = KV*exp(sarg1*NV);
        // idsat = betac*exp(sarg1*NC)`): one ln + two exp instead of two pow.
        if (vgst > 0.0) begin
            lvgon = ln(vgst);                  // vgst > 0 here, no floor needed
            vdsat = max(kv * exp(lvgon * nv), 1e-30);
        end else begin
            lvgon = 0.0;
            vdsat = max(kv * pow(1e-30, nv), 1e-30);
        end
        vdsatm = max(vdsat, 0.025);          // DEVqmeyer MAGIC_VDS floor

        // u = min(vds/vdsat, 1) folds saturation into the linear expression:
        // f(1) = 1, so id = idsat*(1+lam*vds) there. Only C0 in gds at the
        // seam: that is level 6's own behaviour, not a smoothing bug.
        id   = 0.0;
        gmch = 0.0;
        if (vgst > 0.0) begin
            idsat = betac * exp(lvgon * nc);   // shares the ln above
            lam   = lam0 - lambda1 * vbx;
            clm   = 1.0 + lam * vdsx;
            u     = min(vdsx / vdsat, 1.0);
            fu    = (2.0 - u) * u;
            id    = idsat * clm * fu;
            // d(id)/d(vgst), exact for the expression above: the nc*fu term
            // is gm = id*nc/vgst, the second is the blend's du term.
            gmch  = idsat * clm * (nc * fu - 2.0 * nv * u * (1.0 - u)) / vgst;
        end

        // ============ junction and gate charges ===========================
        // Junction depletion charge, bottom + sidewall.
        qbd = qdep(vbd, czbd, pbt, mj, fc) + qdep(vbd, czbdsw, pbt, mjsw, fc);
        qbs = qdep(vbs, czbs, pbt, mj, fc) + qdep(vbs, czbssw, pbt, mjsw, fc);

        // Meyer intrinsic gate capacitances (DEVqmeyer). Values are the
        // steady-state totals (2x the half-caps ngspice stores); the stamps
        // average 0.5*(now + $prev(now)), identical to ngspice's
        // half_now + half_prev MODETRAN sum, with the steady-state total at
        // OP/AC via $prev's commit at OP exit.
        cgsm = 0.0;
        cgdm = 0.0;
        cgbm = 0.0;
        if (vgst <= -phit) begin
            cgbm = cox;                                   // accumulation
        end else if (vgst <= -0.5 * phit) begin
            cgbm = -vgst * cox / phit;                    // depletion
        end else if (vgst <= 0.0) begin
            cgbm  = -vgst * cox / phit;                   // weak inversion
            cbase = vgst * 2.0 * cox / (1.5 * phit) + 2.0 * cox / 3.0;
            if (vdsx >= vdsatm) begin
                cgsm = cbase;
            end else begin
                vdd  = max(2.0 * vdsatm - vdsx, 1e-30);
                vdd1 = vdsatm - vdsx;
                cgsm = cbase * (1.0 - vdd1 * vdd1 / (vdd * vdd));
                cgdm = cbase * (1.0 - vdsatm * vdsatm / (vdd * vdd));
            end
        end else if (vdsx >= vdsatm) begin
            cgsm = 2.0 * cox / 3.0;                       // strong inv, sat
        end else begin
            vdd  = max(2.0 * vdsatm - vdsx, 1e-30);       // strong inv, linear
            vdd1 = vdsatm - vdsx;
            cgsm = 2.0 * cox / 3.0 * (1.0 - vdd1 * vdd1 / (vdd * vdd));
            cgdm = 2.0 * cox / 3.0 * (1.0 - vdsatm * vdsatm / (vdd * vdd));
        end
        // Reversed mode: the channel-side Meyer caps swap terminals.
        if (mode > 0.0) begin
            chgs = cgsm;
            chgd = cgdm;
        end else begin
            chgs = cgdm;
            chgd = cgsm;
        end
        // Constant overlap + averaged Meyer intrinsic.
        // At the operating point $prev is not latched yet, and ngspice's
        // MODETRANOP charge, which the transient's charge history starts
        // from, is (2*half + overlap)*v (mos6load.c).
        // ngspice stamps geq = ag0*C with no dC/dV term (NIintegrate at
        // mos6load.c:875): vera_nodiff keeps the caps coefficients.
        (* vera_nodiff *) if (analysis("static")) begin
            capgs = cgso * weff * m + chgs;
            capgd = cgdo * weff * m + chgd;
            capgb = cgbo * leff * m + cgbm;
        end else begin
            capgs = cgso * weff * m + 0.5 * (chgs + $prev(chgs));
            capgd = cgdo * weff * m + 0.5 * (chgd + $prev(chgd));
            capgb = cgbo * leff * m + 0.5 * (cgbm + $prev(cgbm));
        end
        // The first Newton iteration of a transient step (mos6load.c:821-867).
        // MODEINITPRED extrapolates the gate charges from the last two
        // accepted points. On the host's linear predictor that is the
        // increment since the last accept at that accept's capacitance.
        // MODEINITTRAN, the first step, stamps no gate-cap current or
        // conductance; $abstime > 0 leaves out the t = 0 commit.
        // ngspice's geq keeps the present capacitance, so the extrapolation
        // is a second ddt() site per cap on a frozen copy of the voltage:
        // (pcap - cap)*(V - V_accept) in value, no Jacobian, zero at every
        // accepted point.
        pcapgs = $prev(capgs);
        pcapgd = $prev(capgd);
        pcapgb = $prev(capgb);
        (* vera_nodiff *) begin
            vgsf = V(g, si);
            vgdf = V(g, di);
            vgbf = V(g, b);
        end
        if (analysis("static") || $simparam("iteration") != 1) begin
            pcapgs = capgs;
            pcapgd = capgd;
            pcapgb = capgb;
        end
        @(initial_step("tran")) begin
            if ($abstime > 0.0 && $simparam("iteration") == 1) begin
                capgs = 0.0;
                capgd = 0.0;
                capgb = 0.0;
                pcapgs = 0.0;
                pcapgd = 0.0;
                pcapgb = 0.0;
            end
        end

        // ============ contributions =======================================
        I(di, si) <+ ty * mode * id;
        I(b, di) <+ ty * ibd;
        I(b, si) <+ ty * ibs;
        // qbd/qbs join no LTE check: mos6trun.c truncates qgs, qgd, qgb only.
        (* vera_lte = 0 *) I(b, di) <+ ty * ddt(qbd);
        (* vera_lte = 0 *) I(b, si) <+ ty * ddt(qbs);
        // Meyer caps are capacitance-based, not charge-conserving (ngspice
        // advances q = q_prev + cap*(v - v_prev)), so the Jacobian entry is
        // exactly cap; ddt(cap*v) would add v*dcap/dv. Both plates are
        // evaluated in the type-corrected frame, where the two ty factors
        // cancel.
        I(g, si) <+ capgs * ddt(V(g, si));
        I(g, di) <+ capgd * ddt(V(g, di));
        I(g, b)  <+ capgb * ddt(V(g, b));
        (* vera_lte = 0 *) I(g, si) <+ (pcapgs - capgs) * ddt(vgsf);
        (* vera_lte = 0 *) I(g, di) <+ (pcapgd - capgd) * ddt(vgdf);
        (* vera_lte = 0 *) I(g, b) <+ (pcapgb - capgb) * ddt(vgbf);

        if (gdrain > 0.0) I(d, di) <+ gdrain * V(d, di);
        else V(d, di) <+ 0.0;
        if (gsource > 0.0) I(s, si) <+ gsource * V(s, si);
        else V(s, si) <+ 0.0;

        // ============ noise (mos1noi.c template) ==========================
        if (gdrain > 0.0) I(d, di) <+ white_noise(4.0 * 1.38064852e-23 * tk * gdrain, "rd");
        if (gsource > 0.0) I(s, si) <+ white_noise(4.0 * 1.38064852e-23 * tk * gsource, "rs");
        I(di, si) <+ white_noise(4.0 * 1.38064852e-23 * tk * 2.0 / 3.0 * abs(gmch), "channel");
        // mos1noi.c:319 substitutes a nominal TOX = 1e-7 when Cox' is zero
        // rather than dropping the flicker source.
        if (kf > 0.0)
            I(di, si) <+ flicker_noise(kf * pow(abs(id), af)
                                       / (weff * m * leff * coxn * coxn), 1.0, "flicker");
    end
endmodule
