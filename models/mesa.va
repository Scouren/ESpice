// MESA: unified GaAs MESFET / HEMT (ngspice netlist letter Z,
// `.model ... nmf level=2|3|4`).
//
// Verilog-A implementation: Omar El-Sawy, University of Waterloo.
// Based on: ngspice mesa (mesaload.c, mesatemp.c, mesasetup.c, mesa.c), the
//   MESA model of T. Ytterdal, K. Lee, M. Shur and T. A. Fjeldly.
//   ngspice: Copyright Regents of the University of California and others,
//   modified BSD license.
//
// Structure: §1.4 (structural) + §1.5 (temperature/
// limiting) and §3 (`fet_eval` spine). §1.4 defers the equations to ngspice,
// so they follow mesaload.c/mesatemp.c with the parameter names, defaults and
// units of mesa.c's IOP table. §3's spine:
//   bias -> gate junctions -> mode select on sign(vds) -> charge-control
//   channel -> gate charges -> stamp through the RD/RS/RG/RI/RF series network.
//
// Topology (mesaload.c stamp rows, one internal node per series resistor):
//  dr --RD-- d1 --RF-- d2      g --RG-- g1      s --RS-- s1 --RI-- s2
//   gate junctions g1-s1, g1-d1;  channel d1-s1;  gate charges g1-s2, g1-d2.
// The series elements are voltage branches, so R=0 (the ngspice default, where
// the node is not created at all) is an exact short, not a 1/0 conductance.
//
// Deliberate differences from ngspice:
//   * frequency-dependent lambda (mesaacl.c:39-43): parameters accepted, the
//     tanh(f) dispersion is not expressible in a pure analog block.
//   * `inverse` is recomputed per evaluation; ngspice leaks it across instances
//     in one MESAload call (mesaload.c:91), so multi-Z netlists can differ
//     from ngspice if any device runs at vds < 0.
//   * ngspice's `off` flag / icvds / icvgs cold-start seeds are netlist-level
//     initial conditions, not model equations; the solver owns them.

`include "constants.vams"
`include "disciplines.vams"

module mesa(dr, g, s);
    inout dr, g, s;
    electrical dr, g, s;
    electrical d1, s1, g1, d2, s2;

    branch (dr, d1) brd;    // RD
    branch (s, s1)  brs;    // RS
    branch (g, g1)  brg;    // RG
    branch (s1, s2) bri;    // RI
    branch (d1, d2) brf;    // RF

    // ---- physical constants (ngspice 44 const.h) ----------------------------
    // CONSTboltz, CHARGE and EPSILONGAAS = 12.244*8.85418e-12, as used by
    // mesatemp.c/mesaload.c.  One consistent pair everywhere: vt, the thermionic
    // prefactor and the epi algebra must all see the same k and q, or
    // csatfs/vpo/beta_i drift from the reference (phib's 8.010883104e-20 default
    // is 0.5*CHARGE, mesasetup.c:126, with *this* q).
    localparam real kb       = 1.38064852e-23;  // J/K
    localparam real qe       = 1.6021766208e-19; // C
    localparam real eps_gaas = 1.0841058e-10;   // F/m

    // ---- instance geometry -------------------------------------------------
    parameter real l     = 1.0e-6  from (0:inf);  // m   gate length
    parameter real w     = 20.0e-6 from (0:inf);  // m   gate width
    parameter real dtemp = 0.0;                   // K   instance temp offset
    // Source- and drain-side temperatures (mesa.c:21-22, mesaparam.c:63-70):
    // each given one replaces $temperature + dtemp (mesasetup.c:245-250).
    parameter real ts    = 27.0;                  // degC source-side temperature
    parameter real td    = 27.0;                  // degC drain-side temperature
    // No model TNOM: ngspice refers every tempco to .options tnom
    // (CKTnomTemp, mesatemp.c:60-149) and 44.2 prints "unrecognized parameter
    // (tnom) - ignored" for one on the card, which a degC card value read
    // here as kelvin would not.
    // ngspice's instance parallel multiplier (mesa.c MESApTable `m`, default 1;
    // mesaload.c:422 scales every RHS/Y entry by it).  Named `mult` because the
    // model card's knee shape already owns `m` and a Verilog-A module has one
    // parameter namespace.
    parameter real mult  = 1.0     from (0:inf);  //     parallel devices

    // ---- model selection ---------------------------------------------------
    parameter integer level = 2 from [2:4];  // 2 single layer, 3 delta doped,
                                             // 4 n-dependent mobility

    // ---- dc channel --------------------------------------------------------
    parameter real vto     = -1.26;                  // V     pinch-off
    aliasparam vt0 = vto;                    // ngspice mesa.c:49-50 IOPR spelling
    parameter real beta    = 0.0085  from [0:inf);   //       transconductance
    parameter real vs      = 1.5e5   from (0:inf);   // m/s   saturation vel.
    parameter real lambda  = 0.045;                  // 1/V   output conductance
    parameter real mu      = 0.23    from (0:inf);   // m2/Vs low-field mobility
    parameter real theta   = 0.0;                    // m2/V2s mobility vs vgt
    parameter real mu1     = 0.0     from [0:inf);   // m2/Vs phonon mobility 1
    parameter real mu2     = 0.0     from [0:inf);   // m2/Vs phonon mobility 2
    parameter real eta     = 1.73    from (0:inf);   //       subthreshold ideality
    parameter real m       = 2.5     from (0:inf);   //       knee shape
    parameter real mc      = 3.0     from (0:inf);   //       vdse knee shape
    parameter real alpha   = 0.0;                    // 1/V   knee shape vs vgte
    parameter real tc      = 0.0;                    // 1/V   gm compression
    parameter real delta   = 5.0     from (0:inf);   //       vgte smoothing
    parameter real sigma0  = 0.081;                  //       DIBL amplitude
    parameter real vsigmat = 1.01;                   // V     DIBL turn-off centre
    parameter real vsigma  = 0.1     from (0:inf);   // V     DIBL turn-off width
    parameter real zeta    = 1.0;                    //       beta scaling
    parameter real ks      = 0.0;                    //       sidegating coeff.
    parameter real vsg     = 0.0;                    // V     sidegating voltage
    parameter real ag      = 0.0;                    //       gate-current split

    // ---- layer structure ---------------------------------------------------
    // LRM 3.4/3.6: one identifier namespace per module, so the drain terminal
    // is `dr` and the ngspice model-card keyword `d` stays a plain parameter.
    // (An aliasparam beside a net `d` is E0373 since VerA cc40b0a9.)
    parameter real d      = 0.12e-6  from (0:inf);   // m     channel depth
    parameter real nd     = 2.0e23   from (0:inf);   // 1/m3  channel doping
    parameter real du     = 0.035e-6 from (0:inf);   // m     undoped spacer
    parameter real ndu    = 1.0e22   from (0:inf);   // 1/m3  spacer doping
    parameter real th     = 0.01e-6  from (0:inf);   // m     delta-doped thickness
    parameter real ndelta = 6.0e24   from (0:inf);   // 1/m3  delta-doped density
    parameter real nmax   = 2.0e16   from (0:inf);   // 1/m2  max sheet density
    parameter real gamma  = 3.0      from (0:inf);   //       ns/isat knee (level 4)
    parameter real epsi   = eps_gaas from (0:inf); // F/m   level-4 permittivity
    parameter real cas    = 1.0      from (0:inf);   //       level-4 cgc share a
    parameter real cbs    = 1.0      from (0:inf);   //       level-4 cgc share b

    // ---- gate Schottky junctions ------------------------------------------
    parameter real phib  = 8.010883104e-20 from (0:inf);// J barrier height (0.5 q)
    parameter real phib1 = 0.0;                      // J/K barrier tempco
    parameter real astar = 4.0e4     from (0:inf);   // A/m2K2 Richardson const.
    // ggr enters as ggr*l*w*vgs*exp(...), i.e. a current, so its unit is a
    // conductance per area (mesa.c: "Reverse diode conductance").
    parameter real ggr   = 40.0      from [0:inf);   // S/m2  reverse (GGR) leakage
    parameter real del   = 0.04;                     //       GGR shape
    parameter real xchi  = 0.033;                    // 1/K   GGR tempco
    parameter real n     = 1.0       from (0:inf);   //       emission coefficient
    parameter real gmin  = $simparam("gmin")   from [0:inf);   // S     junction shunt

    // ---- parasitic resistances --------------------------------------------
    parameter real rd  = 0.0 from [0:inf);   // ohm  drain contact
    parameter real rs  = 0.0 from [0:inf);   // ohm  source contact
    parameter real rg  = 0.0 from [0:inf);   // ohm  gate contact
    parameter real ri  = 0.0 from [0:inf);   // ohm  gate-source access
    parameter real rf  = 0.0 from [0:inf);   // ohm  gate-drain access
    parameter real rdi = 0.0 from [0:inf);   // ohm  intrinsic drain
    parameter real rsi = 0.0 from [0:inf);   // ohm  intrinsic source
    parameter real rtc1 = 0.0;               // 1/K  resistance tempco 1
    parameter real rtc2 = 0.0;               // 1/K2 resistance tempco 2

    // ---- temperature coefficients -----------------------------------------
    parameter real tvto    = 0.0;                    // V/K  vto tempco
    parameter real tlambda = 1.0e300;                // K    lambda tempco (inf)
    parameter real teta0   = 1.0e300;                // K    eta tempco (inf)
    parameter real teta1   = 0.0;                    // K    eta tempco
    parameter real tmu     = 300.15 from (0:inf);    // K    mobility ref temp
    parameter real xtm0    = 0.0;                    //      mobility exponent 0
    parameter real xtm1    = 0.0;                    //      mobility exponent 1
    parameter real xtm2    = 0.0;                    //      mobility exponent 2

    // ---- frequency-dependent output conductance (mesaacl.c:39-43) ----------
    // lambda(f) = tLambda + 0.5*(tLambdahf - tLambda)*(1 + tanh((f-fl)/delf)),
    // fl = flo*exp(ts/tf), delf = delfo*exp(ts/tf).  A pure analog block has no
    // frequency variable, so the dispersion itself is NOT expressible here: the
    // parameters are accepted and the DC/low-frequency lambda is used at all
    // frequencies.  Inert at ngspice defaults (delfo = 0 collapses the tanh);
    // it only bites cards that set flo/delfo/lambdahf.
    parameter real lambdahf = lambda;                // 1/V  hf output conductance
    parameter real tf       = 300.15 from (0:inf);   // K    dispersion ref temp
    parameter real flo      = 0.0    from [0:inf);   // Hz   transition frequency
    parameter real delfo    = 0.0    from [0:inf);   // Hz   transition width

    // bias-independent prep (mesatemp.c / mesasetup.c)
    real tempk, tempd, tnom, dtk, dtd, vt, vtj, vtes, vted, etavth, vcrits, vcritd;
    real t_mu, t_phib, t_vto, t_eta, t_lambda;
    real t_rd, t_rs, t_rg, t_ri, t_rf, t_rsi, t_rdi, rt;
    real muimp, mupo, dlay, vpou, vpod, vpo, deltasqr;
    real gchi0, beta_i, n0, nsb0, isatb0, cf, csatfs, csatfd, ggrwl, imax;
    // bias-dependent
    real vgs, vgd, vds, vgsx, vdsx, inv, von;
    real cgs, cgd, cdrain, capgs, capgd, swp;
    real vgt0, vgt, vgte, sig, sfac, uu, tt, mueff, vl, betaq, bexp;
    real sqrt1, ns, nsa, nsb, nsm, gchi, gchim, isat, isata, isatb, isatm;
    real gch, vsate, vdse, knee, gg, hh, pp, cc, rr, ca, cb, cgc, cgcm, ratio;

    analog begin
        // ------------------------------------------------------------------
        // §1.5 temperature map.  All of this is node-voltage independent.
        // ngspice carries separate source/drain temperatures, both
        // CKTtemp + dtemp unless the card gives `ts`/`td`. ts (tempk) sets
        // everything but the drain side: csatfd, the drain junction's vt
        // and rd, rf, rdi (mesatemp.c:46-150, mesaload.c:109-112, 301).
        // ------------------------------------------------------------------
        tempk = $temperature + dtemp;
        tempd = tempk;
        if ($param_given(ts)) tempk = ts + 273.15;
        if ($param_given(td)) tempd = td + 273.15;
        tnom  = $simparam("tnom") + 273.15;  // .options tnom [K]
        dtk   = tempk - tnom;
        dtd   = tempd - tnom;
        vt    = kb * tempk / qe;
        vtj   = kb * tempd / qe;    // drain-junction thermal voltage
        vtes  = n * vt;
        vted  = n * vtj;

        if (mu1 == 0.0 && mu2 == 0.0) begin
            t_mu = mu * pow(tempk / tmu, xtm0);
        end else begin
            muimp = mu * pow(tempk / tmu, xtm0);
            mupo  = mu1 * pow(tmu / tempk, xtm1) + mu2 * pow(tmu / tempk, xtm2);
            t_mu  = 1.0 / (1.0 / muimp + 1.0 / mupo);
        end
        t_phib   = phib - phib1 * dtk;
        t_vto    = vto - tvto * dtk;
        t_eta    = eta * (1.0 + tempk / teta0) + teta1 / tempk;
        t_lambda = lambda * (1.0 - tempk / tlambda);
        etavth   = t_eta * vt;

        // Series resistances: r == 0 keeps the branch an exact short, which is
        // what ngspice's "node not created" case means.
        t_rd  = rd  * (1.0 + rtc1 * dtd + rtc2 * dtd * dtd);
        t_rs  = rs  * (1.0 + rtc1 * dtk + rtc2 * dtk * dtk);
        t_rg  = rg  * (1.0 + rtc1 * dtk + rtc2 * dtk * dtk);
        t_ri  = ri  * (1.0 + rtc1 * dtk + rtc2 * dtk * dtk);
        t_rf  = rf  * (1.0 + rtc1 * dtd + rtc2 * dtd * dtd);
        t_rsi = rsi * (1.0 + rtc1 * dtk + rtc2 * dtk * dtk);
        t_rdi = rdi * (1.0 + rtc1 * dtd + rtc2 * dtd * dtd);
        rt    = t_rsi + t_rdi;

        // Pinch-off voltage of the epi stack (level 2 uniform, 3/4 delta doped).
        if (level == 2) begin
            vpou = 0.0;
            vpod = 0.0;
            vpo  = qe * nd * d * d / 2.0 / eps_gaas;
        end else begin
            vpou = qe * ndu * du * du / 2.0 / eps_gaas;
            vpod = qe * ndelta * th * (2.0 * du + th) / 2.0 / eps_gaas;
            vpo  = vpou + vpod;
        end
        deltasqr = delta * delta;

        // Charge-control prefactors.
        if (level == 2) gchi0 = qe * w / l;
        else            gchi0 = qe * w / l * t_mu;
        beta_i = 2.0 * eps_gaas * vs * zeta * w / d;
        if (level == 3) dlay = du;
        else            dlay = d;
        if (level == 4) n0 = epsi * t_eta * vt / 2.0 / qe / dlay;
        else            n0 = eps_gaas * t_eta * vt / qe / dlay;
        nsb0   = eps_gaas * t_eta * vt / qe / (du + th);
        isatb0 = qe * n0 * vt * w / l;
        if (level == 4) cf = 0.5 * epsi * w;
        else            cf = 0.5 * eps_gaas * w;
        csatfs = 0.5 * astar * tempk * tempk *
                 exp(-t_phib / (kb * tempk)) * l * w;
        csatfd = 0.5 * astar * tempd * tempd *
                 exp(-t_phib / (kb * tempd)) * l * w;
        ggrwl  = ggr * l * w * exp(xchi * dtk);
        imax   = qe * nmax * vs * w;

        // Per-junction critical voltages (mesatemp.c:98-106), the vcrit
        // DEVpnjlim needs at mesaload.c:273-283.
        vcrits = vt  * ln(vt  / (1.4142135623730951 * csatfs));
        vcritd = vtj * ln(vtj / (1.4142135623730951 * csatfd));

        // ------------------------------------------------------------------
        // §3: bias. §1.5 limiting order is fetlim(vgs), fetlim(vgd), limvds,
        // then pnjlim on both gate junctions; only the pnjlim legs are declared
        // here. $limit names the algorithm and critical voltage; the host runs
        // it (as in models/diode.va).
        // ------------------------------------------------------------------
        vgs = $limit(V(g1, s1), "pnjlim", vtes, vcrits);
        vgd = $limit(V(g1, d1), "pnjlim", vted, vcritd);
        vds = vgs - vgd;

        // Gate Schottky diodes: thermionic forward term + GGR reverse leakage.
        cgs = csatfs * (exp(vgs / vtes) - 1.0)
            + ggrwl * vgs * exp(-vgs * del / vt) + gmin * vgs;
        cgd = csatfd * (exp(vgd / vted) - 1.0)
            + ggrwl * vgd * exp(-vgd * del / vtj) + gmin * vgd;

        // Mode select on sign(vds): the inverse case runs the same channel with
        // vgd as the controlling bias, then flips the current and swaps caps.
        if (vds < 0.0) begin
            inv  = 1.0;
            vgsx = vgd;
            vdsx = -vds;
        end else begin
            inv  = 0.0;
            vgsx = vgs;
            vdsx = vds;
        end

        // Sidegating: threshold shift with the intrinsic source potential.
        von = t_vto + ks * (V(s1) - vsg);

        // ------------------------------------------------------------------
        // Charge-control channel.  DIBL-shifted overdrive and the delta-
        // smoothed effective overdrive vgte are common to all three levels.
        // ------------------------------------------------------------------
        vgt0  = vgsx - von;
        sfac  = exp((vgt0 - vsigmat) / vsigma);
        sig   = sigma0 / (1.0 + sfac);
        vgt   = vgt0 + sig * vdsx;
        mueff = t_mu + theta * vgt;

        if (level == 4) begin
            // ---- level 4: carrier-concentration-dependent mobility -------
            bexp   = exp(vgt / etavth);
            nsm    = 2.0 * n0 * ln(1.0 + 0.5 * bexp);
            if (nsm < 1.0e-38) begin
                cdrain = 0.0;
                capgs  = cf;
                capgd  = cf;
            end else begin
                vl     = vs / t_mu * l;
                uu     = 0.5 * vgt / vt - 1.0;
                tt     = sqrt(deltasqr + uu * uu);
                vgte   = vt * (2.0 + uu + tt);
                cc     = pow(nsm / nmax, gamma);
                ns     = nsm / pow(1.0 + cc, 1.0 / gamma);
                gchi   = gchi0 * ns;
                gch    = gchi / (1.0 + gchi * rt);
                gchim  = gchi0 * nsm;
                hh     = sqrt(1.0 + 2.0 * gchim * rsi + vgte * vgte / (vl * vl));
                pp     = 1.0 + gchim * t_rsi + hh;
                isatm  = gchim * vgte / pp;
                gg     = pow(isatm / imax, gamma);
                isat   = isatm / pow(1.0 + gg, 1.0 / gamma);
                knee   = m;
                vsate  = isat / gch;
                ratio  = vdsx / vsate;
                vdse   = vdsx * pow(1.0 + pow(ratio, mc), -1.0 / mc);
                hh     = pow(1.0 + pow(ratio, knee), 1.0 / knee);
                cdrain = gch * vdsx * (1.0 + t_lambda * vdsx) / hh;
                cgcm   = 1.0 / (d / (cas * epsi)
                       + etavth / (cbs * qe * n0) * exp(-vgt / etavth));
                cgc    = w * l * cgcm / pow(1.0 + cc, 1.0 + 1.0 / gamma);
                rr     = (vsate - vdse) / (2.0 * vsate - vdse);
                capgs  = cf + 2.0 / 3.0 * cgc * (1.0 - rr * rr);
                rr     = vsate / (2.0 * vsate - vdse);
                capgd  = cf + 2.0 / 3.0 * cgc * (1.0 - rr * rr);
            end
        end else if (level == 3) begin
            // ---- level 3: delta-doped two-layer charge control ------------
            uu   = vgt / vt - 1.0;
            tt   = sqrt(deltasqr + uu * uu);
            vgte = 0.5 * vt * (2.0 + uu + tt);
            gg   = 2.0 * beta * vgte;
            if (vgt > vpod) begin
                if (vgte > vpo) begin
                    nsa = ndelta * th + ndu * du;
                    ca  = eps_gaas / du;
                end else begin
                    // ponytail: floor keeps ca and its derivative finite at
                    // vgte == vpo, where ngspice divides by zero.
                    rr  = sqrt(max((vpo - vgte) / vpou, 1.0e-30));
                    nsa = ndelta * th + ndu * du * (1.0 - rr);
                    ca  = eps_gaas / du / rr;
                end
            end else begin
                if (vpod - vgte < 0.0) begin
                    nsa = ndelta * th * (1.0 - du / th);
                    ca  = eps_gaas / du;
                end else begin
                    rr  = sqrt(1.0 + ndu / ndelta * (vpod - vgte) / vpou);
                    nsa = ndelta * th * (1.0 - du / th * (rr - 1.0));
                    ca  = eps_gaas / du / rr;
                end
            end
            bexp = exp(vgt / etavth);
            cb   = eps_gaas / (du + th) * bexp;
            nsb  = nsb0 * bexp;
            ns   = nsa * nsb / (nsa + nsb);
            if (ns < 1.0e-38) begin
                cdrain = 0.0;
                capgs  = cf;
                capgd  = cf;
            end else begin
                gchi   = gchi0 * ns;
                gch    = gchi / (1.0 + gchi * rt);
                pp     = sqrt(1.0 + 2.0 * gg * t_rsi);
                pp     = 1.0 + gg * t_rsi + pp;
                isata  = gg * vgte / pp / (1.0 + tc * vgte);
                isatb  = isatb0 * bexp;
                isat   = isata * isatb / (isata + isatb);
                vsate  = isat / gch;
                ratio  = vdsx / vsate;
                vdse   = vdsx * pow(1.0 + pow(ratio, mc), -1.0 / mc);
                hh     = pow(1.0 + pow(ratio, m), 1.0 / m);
                cdrain = gch * vdsx * (1.0 + t_lambda * vdsx) / hh;
                cgc    = w * l * ca * cb / (ca + cb);
                rr     = (vsate - vdse) / (2.0 * vsate - vdse);
                capgs  = cf + 2.0 / 3.0 * cgc * (1.0 - rr * rr);
                rr     = vsate / (2.0 * vsate - vdse);
                capgd  = cf + 2.0 / 3.0 * cgc * (1.0 - rr * rr);
            end
        end else begin
            // ---- level 2: single doped layer, velocity-saturated ----------
            vl    = vs / mueff * l;
            betaq = beta_i / (vpo + 3.0 * vl);
            uu    = vgt / vt - 1.0;
            tt    = sqrt(deltasqr + uu * uu);
            vgte  = 0.5 * vt * (2.0 + uu + tt);
            gg    = 2.0 * betaq * vgte;
            bexp  = exp(-vgt / etavth);
            if (vgte > vpo) sqrt1 = 0.0;
            else            sqrt1 = sqrt(1.0 - vgte / vpo);
            // ponytail: (1 - sqrt1) -> 0 as vgte -> 0 is a 1/0 in ngspice
            // (ns collapses to 0 by inf); the floor gets the same limit with a
            // finite derivative.
            ns = 1.0 / (1.0 / (nd * d * max(1.0 - sqrt1, 1.0e-30)) + bexp / n0);
            if (ns < 1.0e-38) begin
                cdrain = 0.0;
                capgs  = cf;
                capgd  = cf;
            end else begin
                gchi   = gchi0 * mueff * ns;
                gch    = gchi / (1.0 + gchi * rt);
                pp     = sqrt(1.0 + 2.0 * gg * t_rsi);
                pp     = 1.0 + gg * t_rsi + pp;
                isata  = gg * vgte / (pp * (1.0 + tc * vgte));
                isatb  = isatb0 * mueff * exp(vgt / etavth);
                isat   = isata * isatb / (isata + isatb);
                vsate  = isat / gch;
                ratio  = vdsx / vsate;
                vdse   = vdsx * pow(1.0 + pow(ratio, mc), -1.0 / mc);
                knee   = m + alpha * vgte;
                hh     = pow(1.0 + pow(ratio, knee), 1.0 / knee);
                cdrain = gch * vdsx * (1.0 + t_lambda * vdsx) / hh;
                if (vgt > vpo) rr = 0.0;
                else           rr = sqrt(1.0 - vgt / vpo);
                cgc    = w * l * eps_gaas / (rr + bexp) / d;
                rr     = (vsate - vdse) / (2.0 * vsate - vdse);
                capgs  = cf + 2.0 / 3.0 * cgc * (1.0 - rr * rr);
                rr     = vsate / (2.0 * vsate - vdse);
                capgd  = cf + 2.0 / 3.0 * cgc * (1.0 - rr * rr);
            end
        end

        // Undo the inverse-mode frame.
        if (inv > 0.5) begin
            cdrain = -cdrain;
            swp    = capgs;
            capgs  = capgd;
            capgd  = swp;
        end

        // ------------------------------------------------------------------
        // §3 stamps.  `mult` devices in parallel: every current scales up, every
        // series resistance scales down (mesaload.c:422-468 multiplies each RHS
        // and Y entry by m, which for the R branches is the same as R/m).  The
        // intrinsic rsi/rdi stay unscaled — they are folded into gch *before*
        // ngspice applies m, so scaling them here would double-count.
        // ------------------------------------------------------------------
        I(g1, s1) <+ mult * cgs;
        I(g1, d1) <+ mult * cgd;
        I(d1, s1) <+ mult * (cdrain - ag * (cgs - cgd));

        // Ward-Dutton partitioned gate charge (Statz cgs/cgd split), on the
        // access nodes d2/s2.  C*ddt(v), NOT ddt(C*v): ngspice hands capgs/capgd
        // to NIintegrate on the voltage increment (mesaload.c:341-347), so the
        // stamped current is exactly capgs*dv/dt and the AC entry is capgs*ag0.
        // ddt(capgs*v) would add a spurious v*dcapgs/dt of the same order.
        // vera_nodiff drops the dC/dV forward AD would otherwise stamp
        // (mesaload.c:365-370 integrates with capgs/capgd as coefficients).
        (* vera_nodiff *) begin
            capgs = capgs;
            capgd = capgd;
        end
        I(g1, s2) <+ mult * capgs * ddt(V(g1, s2));
        I(g1, d2) <+ mult * capgd * ddt(V(g1, d2));

        V(brd) <+ t_rd / mult * I(brd);
        V(brs) <+ t_rs / mult * I(brs);
        V(brg) <+ t_rg / mult * I(brg);
        V(bri) <+ t_ri / mult * I(bri);
        V(brf) <+ t_rf / mult * I(brf);
    end
endmodule
