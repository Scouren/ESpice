// Voltage-controlled switch (S element, `.model sw`) with four-state hysteresis.
//
// Verilog-A implementation: Omar El-Sawy, University of Waterloo.
// Based on: ngspice S element (sw/swload.c).
//   ngspice: Copyright Regents of the University of California and others,
//   modified BSD license.
//
// Only variables assigned inside an event block persist across evaluations
// (LRM §5.10), so the state is split in two:
//   OUTSIDE the band the position is a pure function of the control value and
//   is computed inline. `cross` fires only when time advances, so this is what
//   keeps `.op` and `.dc` sweeps right.
//   INSIDE the band the position is the held `latched`, written only from
//   `@(initial_step)` and the `@(cross(...))` edges.
// Codes follow §1.2: 2 = HYST_OFF, 3 = HYST_ON, ON = code > 2.5. swload.c's
// REALLY_* states are not stored; outside the band `u` recomputes them.

`include "constants.vams"
`include "disciplines.vams"

module vswitch(p, n, cp, cn);
    inout p, n, cp, cn;
    electrical p, n, cp, cn;

    parameter real vt   = 0.0;                  // V    threshold
    parameter real vh   = 0.0;                  // V    hysteresis half-width
    parameter real ron  = 1.0    from (0:inf);  // ohm  on resistance
    parameter real roff = 1.0e12 from (0:inf);  // ohm  off resistance (1/gmin)
    // Seeds the in-band state for vh > 0 (`ON`/`OFF` on the card,
    // `net_devices.switchFlag`), so a switch that starts inside the band has
    // a defined position.
    parameter integer ic = 0;                   //      >0 = start ON

    integer latched;  // held across evaluations: the in-band memory
    integer on;
    real u, hi, lo, gon, goff;

    analog begin
        gon  = 1.0 / ron;
        goff = 1.0 / roff;

        // Negative hysteresis (§1.2) has the window [vt+vh, vt-vh]: the same
        // rails with roles swapped. |vh| gives the band either way; the sign
        // only selects what happens on entry.
        hi = vt + abs(vh);
        lo = vt - abs(vh);
        u  = V(cp, cn);

        // The .op's in-band state (swload.c): ON or OFF seeds it at
        // MODEINITJCT/INITFIX (:43-60) and vh > 0 keeps it (:69-75). For
        // vh <= 0, :76-88 step from CKTstate1, which no .op writes
        // (REALLY_OFF), to HYST_ON whatever the flag.
        @(initial_step) latched = (ic > 0 || vh <= 0.0) ? 3 : 2;

        // Leaving the band latches the rail it left by. Entering it: vh >= 0
        // keeps the state; vh < 0 flips to the opposite rail (§1.2 oscillator).
        @(cross(u - hi, +1)) latched = 3;                    // -> HYST_ON
        @(cross(u - lo, -1)) latched = 2;                    // -> HYST_OFF
        @(cross(u - hi, -1)) latched = (vh < 0.0) ? 2 : 3;   // ON rail -> band
        @(cross(u - lo, +1)) latched = (vh < 0.0) ? 3 : 2;   // OFF rail -> band

        if (u > hi) on = 1;
        else if (u < lo) on = 0;
        else on = (latched > 2.5) ? 1 : 0;

        // §3 sw_eval: piecewise-constant stamp, dG/du = 0 as in swload.c.
        I(p, n) <+ (on ? gon : goff) * V(p, n);
    end
endmodule
