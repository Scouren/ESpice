// MOS1: Shichman-Hodges MOSFET (netlist letter M, LEVEL=1) with Meyer gate
// capacitances.
//
// Verilog-A implementation: Omar El-Sawy, University of Waterloo.
// Based on: ngspice mos1 (mos1temp.c, mos1load.c, mos1noi.c), the Berkeley
// SPICE2/SPICE3 level-1 MOSFET: Shichman-Hodges drain current, Meyer gate
// capacitances.
//   ngspice: Copyright Regents of the University of California and others,
//   modified BSD license.
//
// Order: bias-independent defaulting, temperature and geometry first, then the
// V()-dependent chain. gm/gds/gmbs and the junction/Meyer conductances are not
// written out: they are derivatives of the currents and charges below, taken
// by forward AD. DEVfetlim/DEVlimvds/DEVpnjlim map to $limit.

`include "constants.vams"
`include "disciplines.vams"

module mos1(d, g, s, b);
    inout d, g, s, b;
    electrical d, g, s, b;
    electrical di, si;              // internal drain/source behind rd/rs

    // ---- polarity -------------------------------------------------------
    parameter real    type   = 1.0;                  // +1 NMOS, -1 PMOS

    // ---- channel (Shichman-Hodges) --------------------------------------
    parameter real    vto    = 0.0;                  // zero-bias threshold [V]
    aliasparam vt0 = vto;                    // ngspice mos1.c:119 IOPR spelling
    parameter real    kp     = 2.0e-5;               // transconductance [A/V^2]
    parameter real    gamma  = 0.0;                  // body effect [sqrt(V)]
    parameter real    phi    = 0.6 from (0:inf);     // surface potential [V]
    parameter real    lambda = 0.0;                  // channel-length modulation [1/V]
    parameter real    tox    = 1.0e-7 from [0:inf);  // oxide thickness (0 == none) [m]
    parameter real    ld     = 0.0;                  // lateral diffusion [m]
    parameter real    u0     = 600.0;                // surface mobility [cm^2/Vs]
    aliasparam uo = u0;
    parameter real    nsub   = 0.0 from [0:inf);     // substrate doping [cm^-3]
    parameter real    nss    = 0.0 from [0:inf);     // surface state density [cm^-2]
    parameter integer tpg    = 1 from [-1:1];        // gate type: +1 opp, -1 same, 0 Al

    // ---- series resistance ---------------------------------------------
    parameter real    rd     = 0.0;                  // drain resistance [ohm]
    parameter real    rs     = 0.0;                  // source resistance [ohm]
    parameter real    rsh    = 0.0;                  // sheet resistance [ohm/square]

    // ---- bulk junctions ------------------------------------------------
    parameter real    is     = 1.0e-14;              // bulk junction sat current [A]
    parameter real    js     = 0.0;                  // bulk junction sat density [A/m^2]
    parameter real    cbd    = 0.0;                  // b-d zero-bias cap [F]
    parameter real    cbs    = 0.0;                  // b-s zero-bias cap [F]
    parameter real    cj     = 0.0;                  // bottom junction cap [F/m^2]
    parameter real    cjsw   = 0.0;                  // sidewall junction cap [F/m]
    parameter real    pb     = 0.8 from (0:inf);     // junction potential [V]
    parameter real    mj     = 0.5 from (0:1);       // bottom grading
    parameter real    mjsw   = 0.5 from (0:1);       // sidewall grading
    parameter real    fc     = 0.5 from (0:1);       // fwd-bias cap coefficient

    // ---- gate overlap capacitance --------------------------------------
    parameter real    cgso   = 0.0;                  // gate-source overlap [F/m]
    parameter real    cgdo   = 0.0;                  // gate-drain overlap [F/m]
    parameter real    cgbo   = 0.0;                  // gate-bulk overlap (per length) [F/m]

    // ---- temperature ---------------------------------------------------
    parameter real    tnom   = $simparam("tnom");    // parameter measurement temp [degC]
    parameter real    gmin   = $simparam("gmin");              // junction conductance floor [S]

    // ---- noise (mos1noi.c) ---------------------------------------------
    parameter real    kf     = 0.0 from [0:inf);     // flicker coefficient
    parameter real    af     = 1.0 from (0:inf);     // flicker exponent
    parameter integer nlev   = 2 from [0:3];         // noise model selection
    parameter real    gdsnoi = 1.0 from [0:inf);     // channel shot noise coefficient (NLEV=3)
    parameter real    temp   = 27.0;                 // instance temperature, overrides $temperature [degC]
    parameter real    dtemp  = 0.0;                  // instance offset from $temperature [K]

    // ---- instance ------------------------------------------------------
    parameter real    l   = 1.0e-4 from (0:inf);  // drawn channel length [m]
    parameter real    w   = 1.0e-4 from (0:inf);  // channel width [m]
    parameter real    ad  = 0.0;                  // drain area [m^2]
    parameter real    as  = 0.0;                  // source area [m^2]
    parameter real    pd  = 0.0;                  // drain perimeter [m]
    parameter real    ps  = 0.0;                  // source perimeter [m]
    parameter real    nrd = 1.0 from [0:inf);     // squares of drain diffusion
    parameter real    nrs = 1.0 from [0:inf);     // squares of source diffusion
    parameter real    m   = 1.0 from (0:inf);     // multiplicity

    // bias-independent prep
    real tk, tnomk, vt, vtnom, fact1, fact2, egfet1, egfet, arg1, argt;
    real pbfact1, pbfact, coxp, phix, gammax, vtox, kpx, ratio4, kpt;
    real fermis, fermig, wkfng, wkfngs, vfb;
    real phio, phit, vbit, ist, jst, pbo, pbt, gmaold, gmanew, cfb, cfsw;
    real leff, beta, cox, isats, isatd, czbd, czbs, czbdsw, czbssw;
    real depcap, argf, sargb, sargs, f2d, f3d, f4d, f2s, f3s, f4s;
    real gdrain, gsource;
    real gmn, sid, alpha, coxn, fln;
    // bias-dependent
    real vgs, vds, vbs, vbd, vgd, mode, vdsx, vgsx, vbx, vcrits, vcritd;
    real vonp, sarg, sarg0, vbx0, von, vgst, vdsat, bp, id, ibs, ibd, qbs, qbd;
    real vdsp, vddif, vddif1, vddif2, cgsp, cgsh, cgdh, cgbh, chgs, chgd;
    real capgs, capgd, capgb;
    real pcapgs, pcapgd, pcapgb, vgsf, vgdf, vgbf;

    // Bulk junction diode (both junctions, same law). The exponent is
    // tangent-continued above 80*vtx: pnjlim keeps Newton iterates below it,
    // but LTE probes and sweep warm starts evaluate unlimited, and a flat
    // clamp there would zero the restoring slope.
    analog function real jcur;
        input v, isat, vtx, gm;
        real v, isat, vtx, gm;
        real u;
        begin
            if (v > -3.0 * vtx) begin
                u = min(v / vtx, 80.0);
                jcur = isat * (exp(u) * (1.0 + (v / vtx - u)) - 1.0) + gm * v;
            end else jcur = gm * v - isat;
        end
    endfunction

    // Body-effect root sqrt(phi - vbs), Taylor-continued above vbs = 0 and
    // floored at 0 (mos1load.c:478-485).
    analog function real sbody;
        input vbx, phit;
        real vbx, phit;
        begin
            if (vbx <= 0.0) sbody = sqrt(phit - vbx);
            else sbody = max(sqrt(phit) - vbx / (2.0 * sqrt(phit)), 0.0);
        end
    endfunction

    // Junction depletion charge: power law below fc*pb, the f2/f3/f4 quadratic
    // above it, bottom + sidewall combined.
    analog function real jchg;
        input v, cz, czsw, pbx, mjx, mjswx, fcx, f2, f3, f4;
        real v, cz, czsw, pbx, mjx, mjswx, fcx, f2, f3, f4;
        real a;
        begin
            // Zero junction capacitance => zero charge (f2/f3/f4 are built
            // from cz/czsw too). mos1load.c:567,628 guard the same way; it
            // skips two pow per junction per iteration on layout netlists
            // that leave CJ/CJSW/CBD/CBS at zero.
            if (cz == 0.0 && czsw == 0.0) jchg = 0.0;
            else if (v < fcx * pbx) begin
                a = 1.0 - v / pbx;
                jchg = pbx * (cz * (1.0 - pow(a, 1.0 - mjx)) / (1.0 - mjx)
                            + czsw * (1.0 - pow(a, 1.0 - mjswx)) / (1.0 - mjswx));
            end else begin
                jchg = f4 + v * (f2 + 0.5 * f3 * v);
            end
        end
    endfunction

    analog begin
        // ============ parameter defaulting (mos1temp.c) ====================
        // $param_given mirrors ngspice's !xxxGiven flags: every default here
        // (KP=2e-5, PHI=0.6, GAMMA=0, VTO=0, TOX=1e-7) is a legal user value.
        tnomk = tnom + 273.15;
        // ngspice's const.h k and q (CODATA 2014), and its vt = T * CONSTKoverQ
        // rounding (main.c:501): CODATA 2018 moves vt by 3.4e-7, which a
        // 256-stage inverter chain amplifies past tolerance.
        vtnom = tnomk * (1.38064852e-23 / 1.6021766208e-19);
        // egfet1 also feeds the work-function defaulting below.
        egfet1 = 1.16 - (7.02e-4 * tnomk * tnomk) / (tnomk + 1108.0);

        // TOX not given (or 0) => no oxide cap and no derived KP (mos1temp.c:61-63).
        if ($param_given(tox) && tox > 0.0) coxp = 3.9 * 8.854214871e-12 / tox;
        else coxp = 0.0;

        phix = phi;
        gammax = gamma;
        vtox = vto;
        // NSUB is a cm^-3 card value; ngspice scales it by 1e6 before both the
        // Ni test and the phi/gamma formulas (mos1temp.c:73-99).
        if ($param_given(nsub) && nsub * 1.0e6 > 1.45e16) begin
            if (!$param_given(phi)) begin
                phix = 2.0 * vtnom * ln(nsub * 1.0e6 / 1.45e16);
                if (phix < 0.1) phix = 0.1;
            end
            // Both remaining overrides divide by Cox', so they need TOX.
            if (coxp > 0.0) begin
                if (!$param_given(gamma))
                    gammax = sqrt(2.0 * 11.7 * 8.854214871e-12
                                  * 1.6021766208e-19 * nsub * 1.0e6) / coxp;
                if (!$param_given(vto)) begin
                    fermis = type * 0.5 * phix;
                    if (tpg != 0.0) begin       // poly gate
                        fermig = tpg * type * 0.5 * egfet1;
                        wkfng = 3.25 + 0.5 * egfet1 - fermig;
                    end else wkfng = 3.2;       // aluminium gate
                    wkfngs = wkfng - (3.25 + 0.5 * egfet1 + fermis);
                    vfb = wkfngs - nss * 1.0e4 * 1.6021766208e-19 / coxp;
                    vtox = vfb + type * (gammax * sqrt(phix) + phix);
                end
            end
        end
        // The U0 path lives inside the TOX-given block in mos1temp.c:66-71, so
        // with no TOX (Cox' = 0) KP keeps its 2e-5 default rather than going 0.
        if ($param_given(kp) || coxp <= 0.0) kpx = kp;
        else kpx = u0 * coxp * 1.0e-4;

        // ============ temperature scaling (mos1temp.c) =====================
        // Device temperature: the instance TEMP, else the circuit's plus DTEMP
        // (ngspice CKTtemp + dtemp rule).
        if ($param_given(temp)) tk = temp + 273.15;
        else tk = $temperature + dtemp;
        vt = tk * (1.38064852e-23 / 1.6021766208e-19);
        fact1 = tnomk / 300.15;
        fact2 = tk / 300.15;
        egfet = 1.16 - (7.02e-4 * tk * tk) / (tk + 1108.0);
        arg1 = -egfet1 / (2.0 * 1.38064852e-23 * tnomk)
             + 1.1150877 / (2.0 * 1.38064852e-23 * 300.15);
        argt = -egfet / (2.0 * 1.38064852e-23 * tk)
             + 1.1150877 / (2.0 * 1.38064852e-23 * 300.15);
        pbfact1 = -2.0 * vtnom * (1.5 * ln(fact1) + 1.6021766208e-19 * arg1);
        pbfact = -2.0 * vt * (1.5 * ln(fact2) + 1.6021766208e-19 * argt);

        ratio4 = (tk / tnomk) * sqrt(tk / tnomk);
        kpt = kpx / ratio4;

        phio = (phix - pbfact1) / fact1;
        phit = fact2 * phio + pbfact;
        vbit = vtox - type * (gammax * sqrt(phix)) + 0.5 * (egfet1 - egfet)
             + type * 0.5 * (phit - phix);

        ist = is * exp(-egfet / vt + egfet1 / vtnom);
        jst = js * exp(-egfet / vt + egfet1 / vtnom);

        pbo = (pb - pbfact1) / fact1;
        pbt = fact2 * pbo + pbfact;
        gmaold = (pb - pbo) / pbo;
        gmanew = (pbt - pbo) / pbo;
        cfb = (1.0 + mj * (4.0e-4 * (tk - 300.15) - gmanew))
            / (1.0 + mj * (4.0e-4 * (tnomk - 300.15) - gmaold));
        cfsw = (1.0 + mjsw * (4.0e-4 * (tk - 300.15) - gmanew))
             / (1.0 + mjsw * (4.0e-4 * (tnomk - 300.15) - gmaold));

        // ============ geometry, junction sizing ===========================
        leff = l - 2.0 * ld;
        // ngspice rejects LD >= L/2; leff divides beta and scales cox, so clamp.
        // ponytail: silent clamp, no diagnostics channel in this frontend.
        if (leff < 1.0e-10) leff = 1.0e-10;
        beta = kpt * m * w / leff;
        cox = coxp * w * leff * m;

        // JS wins only when BOTH areas are given; ngspice decides once for the
        // pair (mos1load.c:128-137), not per junction.
        if (js > 0.0 && ad > 0.0 && as > 0.0) begin
            isatd = jst * ad * m;
            isats = jst * as * m;
        end else begin
            isatd = ist * m;
            isats = ist * m;
        end

        if (cbd > 0.0) czbd = cbd * cfb * m; else czbd = cj * cfb * ad * m;
        if (cbs > 0.0) czbs = cbs * cfb * m; else czbs = cj * cfb * as * m;
        czbdsw = cjsw * cfsw * pd * m;
        czbssw = cjsw * cfsw * ps * m;

        // Forward-region linearization constants (mos1temp.c), so the charge
        // above fc*pb is a plain quadratic.
        depcap = fc * pbt;
        argf = 1.0 - fc;
        sargb = pow(argf, -mj);
        sargs = pow(argf, -mjsw);
        f2d = czbd * (1.0 - fc * (1.0 + mj)) * sargb / argf
            + czbdsw * (1.0 - fc * (1.0 + mjsw)) * sargs / argf;
        f3d = czbd * mj * sargb / (argf * pbt) + czbdsw * mjsw * sargs / (argf * pbt);
        f4d = czbd * pbt * (1.0 - argf * sargb) / (1.0 - mj)
            + czbdsw * pbt * (1.0 - argf * sargs) / (1.0 - mjsw)
            - 0.5 * f3d * depcap * depcap - depcap * f2d;
        f2s = czbs * (1.0 - fc * (1.0 + mj)) * sargb / argf
            + czbssw * (1.0 - fc * (1.0 + mjsw)) * sargs / argf;
        f3s = czbs * mj * sargb / (argf * pbt) + czbssw * mjsw * sargs / (argf * pbt);
        f4s = czbs * pbt * (1.0 - argf * sargb) / (1.0 - mj)
            + czbssw * pbt * (1.0 - argf * sargs) / (1.0 - mjsw)
            - 0.5 * f3s * depcap * depcap - depcap * f2s;

        // ============ series resistance ===================================
        // RD/RS, else RSH*squares, else 0 = node collapse.
        if (rd > 0.0) gdrain = m / rd;
        else if (rsh > 0.0 && nrd > 0.0) gdrain = m / (rsh * nrd);
        else gdrain = 0.0;
        if (rs > 0.0) gsource = m / rs;
        else if (rsh > 0.0 && nrs > 0.0) gsource = m / (rsh * nrs);
        else gsource = 0.0;

        // ============ bias and limiting (mos1load.c) ======================
        // "fetlimds" on both gate legs + "limvds" on the channel makes VerA
        // emit mos1load.c:361-373: fetlim the leg that controls the channel in
        // the sign of the OLD vds (vgs when >= 0, vgd when < 0), limvds, then
        // derive the other leg. "pnjlimds" on both bulk legs is the rung at
        // :376-384: pnjlim one junction, picked by the LIMITED vds, and move
        // only the bulk. The trailing `type` is VerA's frame sign (PMOS limits
        // type*v); the argument after it is the MODEINITJCT seed (:397-407):
        // vgs = type*tVto, vds = 0, vbs = -1.
        vcrits = vt * ln(vt / (1.4142135623730951 * isats));
        vcritd = vt * ln(vt / (1.4142135623730951 * isatd));
        // fetlim's threshold is the von the previous load stored (:351, :535):
        // VerA evaluates a solve-dependent limiter argument at that iterate.
        if (type * V(di, si) >= 0.0) vbx = type * V(b, si);
        else vbx = type * V(b, di);
        vonp = vbit * type + gammax * sbody(vbx, phit);
        vgs = type * $limit(V(g, si), "fetlimds", vonp, type,
                            type * vbit + gammax * sqrt(phit));
        vgd = type * $limit(V(g, di), "fetlimds", vonp, type);
        vds = type * $limit(V(di, si), "limvds", type, 0.0);
        vgd = vgs - vds;
        vbs = type * $limit(V(b, si), "pnjlimds", vt, vcrits, type, -1.0);
        vbd = type * $limit(V(b, di), "pnjlimds", vt, vcritd, type);

        // ============ bulk junctions ======================================
        ibs = jcur(vbs, isats, vt, gmin);
        ibd = jcur(vbd, isatd, vt, gmin);

        // ============ mode swap ===========================================
        // Work in the swapped frame, sign the result with mode.
        if (vds >= 0.0) begin
            mode = 1.0;
            vbx = vbs;
            vgsx = vgs;
        end else begin
            mode = -1.0;
            vbx = vbd;
            vgsx = vgd;
        end
        vdsx = mode * vds;                      // |vds|

        // ============ drain current (Shichman-Hodges) =====================
        // ngspice's gmbs is gm*gamma/(2*sarg) on both branches of the root
        // (mos1load.c:487-491), not the slope of its Taylor continuation
        // above vbx = 0. The frozen copies make AD differentiate
        // sarg - (vbx - vbx0)/(2*sarg) there: same value, ngspice's slope.
        sarg = sbody(vbx, phit);
        if (vbx > 0.0 && sarg > 0.0) begin
            (* vera_nodiff *) sarg0 = sarg;
            (* vera_nodiff *) vbx0 = vbx;
            sarg = sarg0 - (vbx - vbx0) / (2.0 * sarg0);
        end
        von = vbit * type + gammax * sarg;
        vgst = vgsx - von;
        if (vgst > 0.0) vdsat = vgst; else vdsat = 0.0;
        bp = beta * (1.0 + lambda * vdsx);

        if (vgst <= 0.0) id = 0.0;                              // cutoff
        else if (vgst <= vdsx) id = 0.5 * bp * vgst * vgst;      // saturation
        else id = bp * vdsx * (vgst - 0.5 * vdsx);               // linear

        // ============ junction and gate charges ===========================
        qbd = jchg(vbd, czbd, czbdsw, pbt, mj, mjsw, fc, f2d, f3d, f4d);
        qbs = jchg(vbs, czbs, czbssw, pbt, mj, mjsw, fc, f2s, f3s, f4s);

        // Meyer gate capacitances (DEVqmeyer), evaluated in the swapped frame (vgst/vdsx already swapped). The
        // halves are averaged with the last ACCEPTED timepoint below ($prev),
        // mos1load.c's MODETRAN form: capgs = state0 + state1 + overlap.
        if (vdsat > 0.025) vdsp = vdsat; else vdsp = 0.025;
        if (vgst <= -phit) begin
            cgbh = 0.5 * cox;
            cgsh = 0.0;
            cgdh = 0.0;
        end else if (vgst <= -0.5 * phit) begin
            cgbh = -vgst * cox / (2.0 * phit);
            cgsh = 0.0;
            cgdh = 0.0;
        end else begin
            // Weak and strong inversion share one sat/lin split: cox/3 is the
            // vgst -> 0+ limit of the weak-inversion prefactor. Splitting only
            // above vgst = 0 would make capgd jump by 0.5*cox at vgst = 0.
            if (vgst <= 0.0) begin
                cgbh = -vgst * cox / (2.0 * phit);
                cgsp = vgst * cox / (1.5 * phit) + cox / 3.0;
            end else begin
                cgbh = 0.0;
                cgsp = cox / 3.0;
            end
            if (vdsx >= vdsp) begin
                cgsh = cgsp;
                cgdh = 0.0;
            end else begin
                vddif = 2.0 * vdsp - vdsx;
                vddif1 = vdsp - vdsx;
                vddif2 = vddif * vddif;
                cgdh = cgsp * (1.0 - vdsp * vdsp / vddif2);
                cgsh = cgsp * (1.0 - vddif1 * vddif1 / vddif2);
            end
        end
        if (mode > 0.0) begin                   // unswap gs/gd halves
            chgs = cgsh;
            chgd = cgdh;
        end else begin
            chgs = cgdh;
            chgd = cgsh;
        end
        // half_now + half_prev + overlap. Unswapped first: ngspice's state
        // slots are device-frame branches, so a mode flip between timepoints
        // still averages gs with gs. $prev latches at OP exit and per accepted
        // step, so AC and the first transient step read 2*half + overlap (the
        // MODETRANOP/MODEINITSMSIG branch).
        // At the operating point $prev is not latched yet, and ngspice's
        // MODETRANOP charge, which the transient's charge history starts
        // from, is (2*half + overlap)*v (mos1load.c).
        // ngspice stamps geq = ag0*C with no dC/dV term (NIintegrate at
        // mos1load.c:863): vera_nodiff keeps the caps coefficients, so C*ddt(V)
        // linearizes to exactly C.
        (* vera_nodiff *) if (analysis("static")) begin
            capgs = 2.0 * chgs + cgso * w * m;
            capgd = 2.0 * chgd + cgdo * w * m;
            capgb = 2.0 * cgbh + cgbo * leff * m;
        end else begin
            capgs = chgs + $prev(chgs) + cgso * w * m;
            capgd = chgd + $prev(chgd) + cgdo * w * m;
            capgb = cgbh + $prev(cgbh) + cgbo * leff * m;
        end
        // The first Newton iteration of a transient step (mos1load.c:809-867).
        // MODEINITPRED extrapolates the gate charges from the last two
        // accepted points. On the host's linear predictor that is the
        // increment since the last accept at that accept's capacitance.
        // MODEINITTRAN, the first step, stamps no gate-cap current or
        // conductance; $abstime > 0 leaves out the t = 0 commit.
        // ngspice's geq keeps the present capacitance, so the extrapolation
        // is a second ddt() site per cap on a frozen copy of the voltage:
        // (pcap - cap)*(V - V_accept) in value, no Jacobian, zero at every
        // accepted point.
        pcapgs = $prev(capgs);
        pcapgd = $prev(capgd);
        pcapgb = $prev(capgb);
        (* vera_nodiff *) begin
            vgsf = V(g, si);
            vgdf = V(g, di);
            vgbf = V(g, b);
        end
        if (analysis("static") || $simparam("iteration") != 1) begin
            pcapgs = capgs;
            pcapgd = capgd;
            pcapgb = capgb;
        end
        @(initial_step("tran")) begin
            if ($abstime > 0.0 && $simparam("iteration") == 1) begin
                capgs = 0.0;
                capgd = 0.0;
                capgb = 0.0;
                pcapgs = 0.0;
                pcapgd = 0.0;
                pcapgb = 0.0;
            end
        end

        // ============ contributions =======================================
        I(di, si) <+ type * mode * id;
        I(b, di) <+ type * ibd;
        I(b, si) <+ type * ibs;
        // qbd/qbs join no LTE check: mos1trun.c truncates qgs, qgd, qgb only.
        (* vera_lte = 0 *) I(b, di) <+ type * ddt(qbd);
        (* vera_lte = 0 *) I(b, si) <+ type * ddt(qbs);
        // Meyer caps are capacitance-based, not charge-conserving: ngspice
        // advances q_gs = q_gs_prev + capgs*(vgs - vgs_prev), so the Jacobian
        // entry is exactly capgs. ddt(capgs*vgs) would add vgs*dcapgs/dv and
        // transcapacitances. The two `type` factors (capgs' frame and the
        // current) cancel.
        I(g, si) <+ capgs * ddt(V(g, si));
        I(g, di) <+ capgd * ddt(V(g, di));
        I(g, b) <+ capgb * ddt(V(g, b));
        (* vera_lte = 0 *) I(g, si) <+ (pcapgs - capgs) * ddt(vgsf);
        (* vera_lte = 0 *) I(g, di) <+ (pcapgd - capgd) * ddt(vgdf);
        (* vera_lte = 0 *) I(g, b) <+ (pcapgb - capgb) * ddt(vgbf);

        if (gdrain > 0.0) I(d, di) <+ gdrain * V(d, di);
        else V(d, di) <+ 0.0;
        if (gsource > 0.0) I(s, si) <+ gsource * V(s, si);
        else V(s, si) <+ 0.0;

        // ============ noise (mos1noi.c, #84) ==============================
        // RD/RS thermal; channel 4kT*Sid with Sid = (2/3)|gm| (NLEV < 3) or
        // the gdsnoi form (NLEV = 3); flicker per NLEV, Cox' of a 1e-7 oxide
        // when TOX is not given. gm and id carry m, as MOS1gm and MOS1cd do.
        // The noise temperature is the device's, without mos1noi.c's
        // TNOM-degree offset under an instance TEMP (an ngspice 45 bug).
        if (gdrain > 0.0) I(d, di) <+ white_noise(4.0 * 1.38064852e-23 * tk * gdrain, "rd");
        if (gsource > 0.0) I(s, si) <+ white_noise(4.0 * 1.38064852e-23 * tk * gsource, "rs");
        // gm as mos1load.c computes it. ddx() would read 0 here: VerA's
        // noisePsd evaluates on unseeded values.
        if (vgst <= 0.0) gmn = 0.0;
        else if (vgst <= vdsx) gmn = bp * vgst;
        else gmn = bp * vdsx;
        if (nlev < 3) sid = 2.0 / 3.0 * gmn;
        else if (vgst > 0.0) begin
            if (vgst <= vdsx) alpha = 0.0;
            else alpha = 1.0 - vdsx / vdsat;
            sid = 2.0 / 3.0 * beta * vgst * (1.0 + alpha + alpha * alpha) / (1.0 + alpha) * gdsnoi;
        end else sid = 0.0;
        I(di, si) <+ white_noise(4.0 * 1.38064852e-23 * tk * sid, "id");
        coxn = (coxp > 0.0) ? coxp : 3.9 * 8.854214871e-12 / 1.0e-7;
        if (nlev == 0)
            fln = kf * m * pow(abs(id) / m, af) / (leff * leff * coxn);
        else if (nlev == 1)
            fln = kf * m * pow(abs(id) / m, af) / (w * leff * coxn);
        else
            fln = kf * gmn * gmn / (m * w * leff * coxn);
        // NLEV 0/1: 1/f; NLEV 2/3: 1/f^AF.
        I(di, si) <+ flicker_noise(fln, (nlev < 2) ? 1.0 : af, "1overf");
    end
endmodule
