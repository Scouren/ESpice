// Independent current source (I element): DC, AC and the six SPICE transient shapes.
//
// Verilog-A implementation: Omar El-Sawy, University of Waterloo.
// Based on: ngspice I element (isrc/isrcload.c, isrcacct.c; ngspice manual
//   §4.1 "Independent Sources").
//   ngspice: Copyright Regents of the University of California and others,
//   modified BSD license.
//
// vsource.va is this file with V() in place of I(); keep the two in step.
// The waveform parameters keep the `v` spelling (pulse_v1, sin_vo, ...): they
// are positional SPICE arguments, and one spelling lets the builder bind V and
// I cards through the same field names.
//
// Every waveform is an explicit function of `$abstime` (LRM §9.10), with no
// ddt/idt and no state, so the stamp is a pure RHS injection and the Jacobian
// is constant.
//
// WAVEFORM. `waveform` is an integer discriminant set by the builder
// (applySourceWaveform, `Wave` enum):
//   0 = DC   1 = PULSE   2 = SIN   3 = EXP   4 = PWL   5 = SFFM   6 = AM
// Only the selected `if` arm evaluates, so an unused shape costs nothing.
//
// THE -1 SENTINELS ARE LOAD-BEARING. ngspice (TRANinit) defaults PULSE
// TR = TF = TSTEP and PW = PER = TSTOP: properties of the `.tran` card, not of
// the source. They default to -1 here and the builder (resolvePulseDefaults)
// patches them from `.tran`. Unpatched (a Model built directly, e.g. a unit
// test), the guards below give near-instant edges and a never-falling pulse:
// an unspecified PULSE is a STEP, as in ngspice.
//
// BREAKPOINTS. PULSE and PWL corners are declared with `@(timer(start,
// period))` (LRM §5.10.5); VerA turns the set into `contract.nextBreakpoint`.
//   PULSE: 4 periodic timers, one per corner, period = effective PER; this is
//          ngspice's PULSE breakpoint set.
//   PWL:   64 one-shot timers, one per table slot. Unused slots read 0 and
//          collapse onto the `pwl_td` breakpoint, a real corner anyway.
// Event controls cannot sit inside an `if` (LRM §5.8), so every source declares
// the PULSE corners whatever its waveform. With sentinels resolved that is one
// extra interior breakpoint at TD + TSTEP; unresolved, breakpoints at TD and
// TD + 1 ps. Either way: one extra timepoint near t = 0, no change in answer.
// ponytail: 64 timers cost every source 64x2 Instance fields and 64 updates per
// step. Upgrade: a VerA `nextBreakpoint` that walks pwl_times[0:pwl_len-1].
//
// Timer arguments must be constant or parameter expressions (LRM §4.5, E0515),
// and the same sentinel resolutions are needed as ordinary arithmetic in the
// body, so they are macros rather than variables.

`include "constants.vams"
`include "disciplines.vams"

`define P_TR   max(pulse_tr, 1.0e-12)
`define P_TF   max(pulse_tf, 1.0e-12)
// VerA accepts `?:` as a timer start but not as a timer period, and this macro
// feeds both. The sentinel is exactly -1.0, so `max(-pulse_pw, 0)` is exactly
// 1 when unresolved and exactly 0 for any real width.
`define P_PW   (max(pulse_pw, 0.0) + max(-pulse_pw, 0.0) * 1.0e30)
`define P_PER  max(pulse_per, `P_TR + `P_PW + `P_TF + 1.0e-12)

module isource(p, n);
    inout p, n;
    electrical p, n;

    // ---- DC / AC ------------------------------------------------------------
    parameter real dc      = 0.0;    // A    operating-point value
    parameter real acmag   = 1.0;    // A    .AC magnitude
    parameter real acphase = 0.0;    // deg  .AC phase
    parameter integer waveform = 0;  //      shape discriminant, see header

    // ---- PULSE(I1 I2 TD TR TF PW PER PHASE) ---------------------------------
    parameter real pulse_v1    =  0.0;  // A    initial value
    parameter real pulse_v2    =  0.0;  // A    pulsed value
    parameter real pulse_td    =  0.0;  // s    delay
    parameter real pulse_tr    = -1.0;  // s    rise time   (-1 = TSTEP)
    parameter real pulse_tf    = -1.0;  // s    fall time   (-1 = TSTEP)
    parameter real pulse_pw    = -1.0;  // s    pulse width (-1 = TSTOP)
    parameter real pulse_per   = -1.0;  // s    period      (-1 = TSTOP)
    parameter real pulse_phase =  0.0;  // deg  phase offset into the period

    // ---- SIN(IO IA FREQ TD THETA PHASE) -------------------------------------
    parameter real sin_vo    = 0.0;  // A    offset
    parameter real sin_va    = 0.0;  // A    amplitude
    parameter real sin_freq  = 0.0;  // Hz   frequency
    parameter real sin_td    = 0.0;  // s    delay
    parameter real sin_theta = 0.0;  // 1/s  damping factor
    parameter real sin_phase = 0.0;  // deg  phase

    // ---- EXP(I1 I2 TD1 TAU1 TD2 TAU2) ---------------------------------------
    parameter real exp_v1   = 0.0;     // A  initial value
    parameter real exp_v2   = 0.0;     // A  pulsed value
    parameter real exp_td1  = 0.0;     // s  rise delay
    parameter real exp_tau1 = 1.0e-9;  // s  rise time constant
    parameter real exp_td2  = 0.0;     // s  fall delay
    parameter real exp_tau2 = 1.0e-9;  // s  fall time constant

    // ---- PWL(T1 I1 T2 I2 ... [R=<t>] [TD=<t>]) ------------------------------
    // VerA flattens `real x[0:63]` into 64 scalar Model fields and lowers a
    // runtime index over them to one `switch` (lower.zig lowerIndex), so the
    // bisection below costs ceil(log2(pwl_len)) switch reads.
    // ponytail: bisection, not ngspice's per-instance breakpoint cursor. The
    // cursor saves ~3 reads on a 10-point table but is state that must rewind
    // on a rejected step; bisection is stateless. Upgrade for 1000-point
    // tables: an Instance cursor latched in updateState and reverted by
    // stateCtl(.revert), with bisection as its oracle.
    parameter real pwl_times[0:63]  = '{0.0, 0.0, 0.0, 0.0, 0.0, 0.0, 0.0, 0.0, 0.0, 0.0, 0.0, 0.0, 0.0, 0.0, 0.0, 0.0, 0.0, 0.0, 0.0, 0.0, 0.0, 0.0, 0.0, 0.0, 0.0, 0.0, 0.0, 0.0, 0.0, 0.0, 0.0, 0.0, 0.0, 0.0, 0.0, 0.0, 0.0, 0.0, 0.0, 0.0, 0.0, 0.0, 0.0, 0.0, 0.0, 0.0, 0.0, 0.0, 0.0, 0.0, 0.0, 0.0, 0.0, 0.0, 0.0, 0.0, 0.0, 0.0, 0.0, 0.0, 0.0, 0.0, 0.0, 0.0};
    parameter real pwl_values[0:63] = '{0.0, 0.0, 0.0, 0.0, 0.0, 0.0, 0.0, 0.0, 0.0, 0.0, 0.0, 0.0, 0.0, 0.0, 0.0, 0.0, 0.0, 0.0, 0.0, 0.0, 0.0, 0.0, 0.0, 0.0, 0.0, 0.0, 0.0, 0.0, 0.0, 0.0, 0.0, 0.0, 0.0, 0.0, 0.0, 0.0, 0.0, 0.0, 0.0, 0.0, 0.0, 0.0, 0.0, 0.0, 0.0, 0.0, 0.0, 0.0, 0.0, 0.0, 0.0, 0.0, 0.0, 0.0, 0.0, 0.0, 0.0, 0.0, 0.0, 0.0, 0.0, 0.0, 0.0, 0.0};
    parameter integer pwl_len = 0;    //    points filled
    parameter real pwl_repeat = -1.0; // s  `r=<t>`: replay [r, t_last]; < 0 = no repeat
    parameter real pwl_td     = 0.0;  // s  `td=<t>`

    // ---- SFFM(IO IA FM MDI FC TD PHASEM PHASEC) -----------------------------
    // Same slots and defaults as vsource.va (isrcload.c:213-227), but
    // isrcload.c reads its phases one slot early: PHASEM is the 6th argument
    // (sffm_td, the same slot as TD, 222-225) and PHASEC the 7th (sffm_phasem,
    // 226-227); TD itself is never applied and the 8th argument is unused.
    parameter real sffm_vo     =  0.0;  // A    offset
    parameter real sffm_va     =  0.0;  // A    amplitude
    parameter real sffm_fm     = -1.0;  // Hz   modulating frequency (-1 = 5/TSTOP)
    parameter real sffm_mdi    = 90.0;  //      modulation index
    parameter real sffm_fc     =  0.0;  // Hz   carrier frequency    (0 = 500/TSTOP)
    parameter real sffm_td     =  0.0;  // deg  6th arg: modulation phase (see above)
    parameter real sffm_phasem =  0.0;  // deg  7th arg: carrier phase (see above)
    parameter real sffm_phasec =  0.0;  //      8th arg: unused by isrcload.c

    // ---- AM(IA IO MF FC TD PHASEC PHASES OFF) -------------------------------
    parameter real am_va     = 0.0;  // A    amplitude
    parameter real am_vo     = 0.0;  //      envelope offset (dimensionless)
    parameter real am_mf     = 0.0;  // Hz   modulating frequency
    parameter real am_fc     = 0.0;  // Hz   carrier frequency
    parameter real am_td     = 0.0;  // s    delay
    parameter real am_phasec = 0.0;  // deg  carrier phase
    parameter real am_phases = 0.0;  // deg  modulation phase
    parameter real am_off    = 0.0;  // A    output offset past TD (ngspice's VO)

    real t, out;
    real p_tr, p_tf, p_pw, p_per, t_rel, t_mod;
    real t_sin, t_e1, t_e2, fm_mdi, am_env, am_car;
    real t_e, t_first, t_last, v_first, v_last, tp, vp, tk, vk, span, excess;
    integer k, klo, khi;

    analog begin
        // Corner-time events, see BREAKPOINTS in the header.
        @(timer(pulse_td, `P_PER)) ;
        @(timer(pulse_td + `P_TR, `P_PER)) ;
        @(timer(pulse_td + `P_TR + `P_PW, `P_PER)) ;
        @(timer(pulse_td + `P_TR + `P_PW + `P_TF, `P_PER)) ;
        @(timer(pwl_times[0] + pwl_td)) ;
        @(timer(pwl_times[1] + pwl_td)) ;
        @(timer(pwl_times[2] + pwl_td)) ;
        @(timer(pwl_times[3] + pwl_td)) ;
        @(timer(pwl_times[4] + pwl_td)) ;
        @(timer(pwl_times[5] + pwl_td)) ;
        @(timer(pwl_times[6] + pwl_td)) ;
        @(timer(pwl_times[7] + pwl_td)) ;
        @(timer(pwl_times[8] + pwl_td)) ;
        @(timer(pwl_times[9] + pwl_td)) ;
        @(timer(pwl_times[10] + pwl_td)) ;
        @(timer(pwl_times[11] + pwl_td)) ;
        @(timer(pwl_times[12] + pwl_td)) ;
        @(timer(pwl_times[13] + pwl_td)) ;
        @(timer(pwl_times[14] + pwl_td)) ;
        @(timer(pwl_times[15] + pwl_td)) ;
        @(timer(pwl_times[16] + pwl_td)) ;
        @(timer(pwl_times[17] + pwl_td)) ;
        @(timer(pwl_times[18] + pwl_td)) ;
        @(timer(pwl_times[19] + pwl_td)) ;
        @(timer(pwl_times[20] + pwl_td)) ;
        @(timer(pwl_times[21] + pwl_td)) ;
        @(timer(pwl_times[22] + pwl_td)) ;
        @(timer(pwl_times[23] + pwl_td)) ;
        @(timer(pwl_times[24] + pwl_td)) ;
        @(timer(pwl_times[25] + pwl_td)) ;
        @(timer(pwl_times[26] + pwl_td)) ;
        @(timer(pwl_times[27] + pwl_td)) ;
        @(timer(pwl_times[28] + pwl_td)) ;
        @(timer(pwl_times[29] + pwl_td)) ;
        @(timer(pwl_times[30] + pwl_td)) ;
        @(timer(pwl_times[31] + pwl_td)) ;
        @(timer(pwl_times[32] + pwl_td)) ;
        @(timer(pwl_times[33] + pwl_td)) ;
        @(timer(pwl_times[34] + pwl_td)) ;
        @(timer(pwl_times[35] + pwl_td)) ;
        @(timer(pwl_times[36] + pwl_td)) ;
        @(timer(pwl_times[37] + pwl_td)) ;
        @(timer(pwl_times[38] + pwl_td)) ;
        @(timer(pwl_times[39] + pwl_td)) ;
        @(timer(pwl_times[40] + pwl_td)) ;
        @(timer(pwl_times[41] + pwl_td)) ;
        @(timer(pwl_times[42] + pwl_td)) ;
        @(timer(pwl_times[43] + pwl_td)) ;
        @(timer(pwl_times[44] + pwl_td)) ;
        @(timer(pwl_times[45] + pwl_td)) ;
        @(timer(pwl_times[46] + pwl_td)) ;
        @(timer(pwl_times[47] + pwl_td)) ;
        @(timer(pwl_times[48] + pwl_td)) ;
        @(timer(pwl_times[49] + pwl_td)) ;
        @(timer(pwl_times[50] + pwl_td)) ;
        @(timer(pwl_times[51] + pwl_td)) ;
        @(timer(pwl_times[52] + pwl_td)) ;
        @(timer(pwl_times[53] + pwl_td)) ;
        @(timer(pwl_times[54] + pwl_td)) ;
        @(timer(pwl_times[55] + pwl_td)) ;
        @(timer(pwl_times[56] + pwl_td)) ;
        @(timer(pwl_times[57] + pwl_td)) ;
        @(timer(pwl_times[58] + pwl_td)) ;
        @(timer(pwl_times[59] + pwl_td)) ;
        @(timer(pwl_times[60] + pwl_td)) ;
        @(timer(pwl_times[61] + pwl_td)) ;
        @(timer(pwl_times[62] + pwl_td)) ;
        @(timer(pwl_times[63] + pwl_td)) ;

        t = $abstime;

        // A zero TR/TF is an instant edge and, as a divisor, a NaN: 1 ps is the
        // smallest edge the engine resolves. An unresolved PW/PER means "high
        // forever". PER is clamped up to TR+PW+TF as in ngspice (isrcload.c),
        // which also guards PER = 0 in the modulo.
        p_tr  = `P_TR;
        p_tf  = `P_TF;
        p_pw  = `P_PW;
        p_per = `P_PER;

        out = dc;

        // ngspice's TRANOP/DCOP split: the transient's own operating point
        // (the ic phase, where analysis("tran") is also true) evaluates the
        // waveform at t = 0; .op/.dc/.ac bias at `dc`, which the builder fills
        // from waveform(0) when the card gives none and a .dc sweep overrides.
        if (analysis("static") && !analysis("tran")) begin
            out = dc;
        end else if (waveform == 1) begin
            // ---- PULSE: I1 until TD, then the trapezoid with period PER.
            // PHASE is a fraction of the period (degrees of 360), not of 2*pi.
            t_rel = t - pulse_td;
            t_mod = t_rel + (pulse_phase / 360.0) * p_per;
            t_mod = t_mod - floor(t_mod / p_per) * p_per;
            t_mod = max(t_mod, 0.0);
            if (t_rel < 0.0)                     out = pulse_v1;
            else if (t_mod < p_tr)               out = pulse_v1 + (pulse_v2 - pulse_v1) * (t_mod / p_tr);
            else if (t_mod < p_tr + p_pw)        out = pulse_v2;
            else if (t_mod < p_tr + p_pw + p_tf) out = pulse_v2 - (pulse_v2 - pulse_v1) * ((t_mod - (p_tr + p_pw)) / p_tf);
            else                                 out = pulse_v1;

        end else if (waveform == 2) begin
            // ---- SIN: before TD the value is IO + IA*sin(PHASE), the
            // waveform's own t = 0 value, so a phase-shifted SIN does not step
            // at TD. The damping envelope applies only after TD; its exponent
            // is clamped so the prover sees a finite product.
            t_sin = t - sin_td;
            if (t_sin < 0.0)
                out = sin_vo + sin_va * sin(sin_phase * `M_PI / 180.0);
            else
                out = sin_vo + sin_va
                    * sin(`M_TWO_PI * sin_freq * t_sin + sin_phase * `M_PI / 180.0)
                    * exp(min(-sin_theta * t_sin, 80.0));

        end else if (waveform == 3) begin
            // ---- EXP, isrcload.c:177-204: I1 up to and at TD1 (195-196),
            // then the rise, plus the fall once past TD2 too. TD2 < TD1
            // holds I1 to TD1 and steps there, as ngspice does.
            t_e1 = t - exp_td1;
            t_e2 = t - exp_td2;
            out = exp_v1;
            if (t_e1 > 0.0) begin
                out = out + (exp_v2 - exp_v1) * (1.0 - exp(min(-t_e1 / max(exp_tau1, 1.0e-15), 80.0)));
                if (t_e2 > 0.0) out = out + (exp_v1 - exp_v2) * (1.0 - exp(min(-t_e2 / max(exp_tau2, 1.0e-15), 80.0)));
            end

        end else if (waveform == 4) begin
            // ---- PWL: an empty table is the DC value (already in `out`).
            if (pwl_len > 0) begin
                t_e = t - pwl_td;
                t_first = pwl_times[0];
                v_first = pwl_values[0];
                t_last = pwl_times[pwl_len - 1];
                v_last = pwl_values[pwl_len - 1];

                // `r=<t>`: past the last point, jump back to time r and replay
                // [r, t_last] forever.
                if (pwl_repeat >= 0.0 && pwl_len > 1 && t_e > t_last && t_last > pwl_repeat) begin
                    span = t_last - pwl_repeat;
                    if (span > 0.0) begin
                        excess = t_e - pwl_repeat;
                        t_e = pwl_repeat + (excess - floor(excess / span) * span);
                    end
                end

                if (t_e < 0.0 || t_e <= t_first)  out = v_first;
                else if (t_e >= t_last)           out = v_last;
                else begin
                    // Bisection over the sorted times. Invariant (from the
                    // guards above, t_first < t_e < t_last):
                    //     pwl_times[klo] <= t_e < pwl_times[khi]
                    // It exits at khi = klo+1, the smallest khi with
                    // pwl_times[khi] > t_e: the unique segment a linear scan
                    // would pick, repeated knots included.
                    klo = 0;
                    khi = pwl_len - 1;
                    while (khi - klo > 1) begin
                        k = (klo + khi) / 2;
                        if (pwl_times[k] > t_e) khi = k; else klo = k;
                    end
                    tp = pwl_times[klo];
                    vp = pwl_values[klo];
                    tk = pwl_times[khi];
                    vk = pwl_values[khi];
                    // Coincident times (a vertical step) would divide by zero;
                    // 1 fs makes it the steepest expressible ramp.
                    out = vp + (vk - vp) * (t_e - tp) / max(tk - tp, 1.0e-15);
                end
            end

        end else if (waveform == 5) begin
            // ---- SFFM, isrcload.c:206-254. MDI is limited to FC/FM, or
            // raised to 0 (229-243); no delay, and the phases are the slots
            // named in the parameter block (250-252). No breakpoints
            // (isrcacct.c:171-174).
            fm_mdi = sffm_mdi;
            if (fm_mdi > sffm_fc / sffm_fm) fm_mdi = sffm_fc / sffm_fm;
            else if (fm_mdi < 0.0) fm_mdi = 0.0;
            out = sffm_vo + sffm_va * sin((`M_TWO_PI * sffm_fc * t + sffm_phasem * `M_PI / 180.0)
                + fm_mdi * sin(`M_TWO_PI * sffm_fm * t + sffm_td * `M_PI / 180.0));

        end else if (waveform == 6) begin
            // ---- AM: OFF + IA * (IO + sin(2*pi*MF*t + PHASES)) * sin(2*pi*FC*t + PHASEC),
            // and 0 up to and at TD (IO is a dimensionless envelope offset,
            // OFF the output offset). ngspice is 0 at t - TD <= 0, its VO
            // included (isrcload.c:280-286), so 0 at t = 0 even when TD = 0.
            if (t > am_td) begin
                am_env = am_vo + sin(`M_TWO_PI * am_mf * t + am_phases * `M_PI / 180.0);
                am_car = sin(`M_TWO_PI * am_fc * t + am_phasec * `M_PI / 180.0);
                out = am_off + am_va * am_env * am_car;
            end else
                out = 0.0;
        end

        // Source stepping (ngspice CKTsrcFact): the OP ladder's homotopy
        // scales every independent source; 1 everywhere else.
        I(p, n) <+ out * $simparam("sourceScaleFactor", 1.0);
    end
endmodule

`undef P_TR
`undef P_TF
`undef P_PW
`undef P_PER
