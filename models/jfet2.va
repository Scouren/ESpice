// JFET2: Parker-Skellern MESFET/JFET model (ngspice J, level 2).
//
// Verilog-A implementation: Omar El-Sawy, University of Waterloo.
// Based on: ngspice J level 2 (jfet2/psmodel.c, jfet2load.c, jfet2temp.c,
//   jfet2noi.c), the Parker-Skellern model (A. E. Parker and D. J. Skellern,
//   Macquarie University).
//   ngspice: Copyright Regents of the University of California and others,
//   modified BSD license.
//
// Topology: D-RD-d', S-RS-s', gate junctions g-d' and g-s' with forward
// exponential and reverse breakdown, and the PS dual-power-law channel between
// d' and s' with source-drain reversal, subthreshold softplus, velocity
// saturation, CLM and self-heating.
//
// Rate dependence: psmodel.c's discrete filters
// (v_trap = h*v_trap_prev + (1-h)*v, h = (taug/(taug+dt/4))^4) are written as
// single-pole ddt lowpasses on internal nodes ntgs/ntgd (gate traps,
// tau = taug) and ntp (dissipated power, tau = taud). ddt() is gated by
// analysis("tran") because the reference uses h = 0 in DC and AC.

`include "constants.vams"
`include "disciplines.vams"

module jfet2(d, g, s);
    inout d, g, s;
    electrical d, g, s;
    electrical di, si;           // d', s' behind RD/RS
    electrical ntgs, ntgd, ntp;  // filter states: vgs_trap, vgd_trap, Pavg
    branch (d, di) brd;
    branch (s, si) brs;

    // +1 = NJF, -1 = PJF. ngspice carries this in the .model name; JFET2type
    // multiplies vgs/vgd and every stamped current/charge.
    parameter integer jtype = 1 from [-1:1] exclude 0;

    // ---- instance ----------------------------------------------------------
    parameter real area  = 1.0  from (0:inf);            // area factor
    parameter real m     = 1.0  from (0:inf);            // multiplicity
    parameter real temp  = 27.0 from (-273.15:inf);      // degC
    parameter real dtemp = 0.0;                          // degC offset
    parameter real tnom  = $simparam("tnom") from (-273.15:inf);  // degC

    // ---- channel -----------------------------------------------------------
    parameter real beta   = 1e-4 from (0:inf);   // A/V^Q
    parameter real vto    = -2.0;                // V
    aliasparam vt0 = vto;                    // ngspice jfet2parm.h:49-50 IOPR spelling
    parameter real lambda = 0.0;                 // 1/V (ngspice accepts < 0)
    parameter real p      = 2.0  from (0:inf);   // triode-region power law
    parameter real q      = 2.0  from [1:inf);   // saturated-region power law
    parameter real z      = 1.0  from [0:inf);   // rate of velocity saturation
    parameter real xi     = 1000.0 from (0:inf); // velocity saturation index
    parameter real mxi    = 0.0;                 // knee potential modulation
    parameter real delta  = 0.0  from [0:inf);   // thermal current reduction, 1/W
    parameter real vst    = 0.0  from [0:inf);   // subthreshold potential
    parameter real mvst   = 0.0;                 // subthreshold modulation
    // PS version selector. psmodel.c only branches on it for pre-release
    // equation variants not carried here; declared so a card naming it parses.
    parameter integer ver = 0 from [0:inf);

    // ---- threshold feedback (trapping / self-heating memory) ---------------
    parameter real lfgam = 0.0;
    parameter real lfg1  = 0.0;
    parameter real lfg2  = 0.0;
    parameter real hfgam = 0.0;
    parameter real hfg1  = 0.0;
    parameter real hfg2  = 0.0;
    parameter real hfeta = 0.0;
    parameter real hfe1  = 0.0;
    parameter real hfe2  = 0.0;
    parameter real taug  = 0.0 from [0:inf);
    parameter real taud  = 0.0 from [0:inf);

    // ---- parasitics and gate junctions ------------------------------------
    parameter real rd  = 0.0   from [0:inf);
    parameter real rs  = 0.0   from [0:inf);
    parameter real is  = 1e-14 from [0:inf);   // IS = 0 => no gate current
    parameter real n   = 1.0   from (0:inf);
    parameter real ibd = 0.0   from [0:inf);
    parameter real vbd = 1.0   from [0:inf);   // VBD = 0 => no breakdown branch
    parameter real pb  = 1.0   from (0:inf);
    parameter real fc  = 0.5   from [0:1);
    parameter real cgs = 0.0   from [0:inf);
    parameter real cgd = 0.0   from [0:inf);
    parameter real cds = 0.0   from [0:inf);
    parameter real xc  = 0.0   from [0:1];     // XC = 1 => full cap reduction
    parameter real acgam = 0.0;
    parameter real gmin  = $simparam("gmin") from [0:inf); // S, .options gmin unless the card sets it
    parameter real kf    = 0.0 from [0:inf);     // flicker coefficient
    parameter real af    = 1.0 from (0:inf);     // flicker exponent

    // Gate junction: forward exponential with the -10/+40 exp-argument
    // continuations plus the reverse breakdown branch, both C1 at the joins.
    analog function real gjunc;
        input v, isat, nvt, ibrk, vbrk, gmn;
        real v, isat, nvt, ibrk, vbrk, gmn;
        real arg, ifwd, irev;
        begin
            arg = v / nvt;
            if (arg <= -10.0)
                ifwd = -isat;
            else if (arg < 40.0)
                ifwd = isat * (exp(arg) - 1.0);
            else
                ifwd = isat * 2.3538526683702e17 * (arg - 39.0) - isat;
            // VBD = 0 or IBD = 0 disables breakdown (no divide by zero).
            irev = 0.0;
            if (ibrk > 0.0 && vbrk > 0.0) begin
                arg = -v / vbrk;
                if (arg <= -10.0)
                    irev = ibrk;
                else if (arg < 40.0)
                    irev = ibrk - ibrk * exp(arg);
                else
                    irev = ibrk - ibrk * 2.3538526683702e17 * (arg - 39.0);
            end
            gjunc = ifwd + irev + gmn * v;
        end
    endfunction

    // bias-independent prep
    real aeff, tdev, tnomk, vt, vtnom, nvt, fact1, fact2, egfet, egnom;
    real argt, argn, pbfact, pbfactn, pbo, gmaold, gmanew, cjfact, cjfact1;
    real pb_t, isat, ibrk, vcrit, grd, grs, fourkt, htr;
    real woo, xiwoo, za, d3, czgs, czgd, alphac, vmax;
    // V()-dependent chain
    real vgs, vgd, vds, vgsf, vgdf, mode, vdse;
    real vgsa, vgda, vgsat, vgdat, lfgt, hfgt, hfet, vgst, vgt, vstx, sarg;
    real vgte, vdp, vsatf, vsat, aa, aaa, argz, vdt, vgm, idr, idclm, id, pbar;
    real vert, veff, vnr, vnrt, vnew, qrt, vx, par, ext, qgg, cfac, cgso;
    real cpm, cplus, cminus, ccgs, ccgd, ctot, qgs, qgd, gm;

    analog begin
        aeff = area * m;
        // ---- temperature: the SPICE junction map (jfet2temp.c), hardwired
        // to 1.11 eV silicon. VTO/BETA have no tempco on the JFET2 card, so
        // only the junction moves.
        tnomk = tnom + 273.15;
        // The instance TEMP, else the circuit's plus DTEMP (jfet2temp.c).
        if ($param_given(temp)) tdev = temp + 273.15;
        else tdev = $temperature + dtemp;
        vt    = 1.38064852e-23 / 1.6021766208e-19 * tdev;
        vtnom = 1.38064852e-23 / 1.6021766208e-19 * tnomk;
        nvt   = vt * n;
        fact1 = tnomk / 300.15;
        fact2 = tdev / 300.15;
        egfet = 1.16 - 7.02e-4 * tdev * tdev / (tdev + 1108.0);
        egnom = 1.16 - 7.02e-4 * tnomk * tnomk / (tnomk + 1108.0);
        // jfet2temp.c's own arithmetic, so the rounding matches too.
        argt    = -egfet / (2.0 * 1.38064852e-23 * tdev) + 1.1150877 / (1.38064852e-23 * (300.15 + 300.15));
        argn    = -egnom / (2.0 * 1.38064852e-23 * tnomk) + 1.1150877 / (1.38064852e-23 * (300.15 + 300.15));
        pbfact  = -2.0 * vt * (1.5 * ln(fact2) + 1.6021766208e-19 * argt);
        pbfactn = -2.0 * vtnom * (1.5 * ln(fact1) + 1.6021766208e-19 * argn);
        pbo     = (pb - pbfactn) / fact1;
        gmaold  = (pb - pbo) / pbo;
        cjfact  = 1.0 / (1.0 + 0.5 * (4e-4 * (tnomk - 300.15) - gmaold));
        pb_t    = fact2 * pbo + pbfact;
        gmanew  = (pb_t - pbo) / pbo;
        cjfact1 = 1.0 + 0.5 * (4e-4 * (tdev - 300.15) - gmanew);
        isat = is * aeff * exp((tdev / tnomk - 1.0) * 1.11 / nvt);
        ibrk = ibd * aeff;
        // Vcrit per gate junction. IS = 0 has no junction to limit.
        if (isat > 0.0) vcrit = nvt * ln(nvt / (1.4142135623730951 * isat));
        else            vcrit = 0.6;
        fourkt = 4.0 * 1.38064852e-23 * tdev;
        // rd/rs = 0 is ngspice's node collapse (JFET2setup), written as a
        // switch branch below.
        grd = 0.0;
        grs = 0.0;
        if (rd > 0.0) grd = aeff / rd;
        if (rs > 0.0) grs = aeff / rs;

        woo   = pb - vto;
        xiwoo = xi * woo;                       // channel: vsat -> vgt at XI >> 1
        za    = sqrt(1.0 + z) / 2.0;
        d3    = p / (q * pow(woo, p - q));
        czgs  = cgs * aeff * cjfact * cjfact1;
        czgd  = cgd * aeff * cjfact * cjfact1;
        // Charge-model smoothing: O((woo/(xi+1))^2) so that vert -> |vds| and
        // C(0) = CGS at zero bias. Not the channel's xi*woo: with it xi cancels
        // and vert(0) = woo/2, which puts a default card in the FC
        // forward-extension branch with qgg(0) != 0.
        alphac = woo * woo / (4.0 * (xi + 1.0) * (xi + 1.0));
        vmax   = fc * pb_t;

        // ---- bias: polarity-normalized (all math below is NJF) and limited.
        // ngspice's fetlim -> limvds -> pnjlim chain cannot be spelled with one
        // $limit per probe, so the junction limiter, which bounds the
        // exponential, is requested. MODEINITJCT's vgs = -1 seed has no
        // Verilog-A spelling.
        vgs = jtype * $limit(V(g, si), "pnjlim", nvt, vcrit);
        vgd = jtype * $limit(V(g, di), "pnjlim", nvt, vcrit);
        vds = vgs - vgd;

        // Trap filters: tau*dV/dt = v - V, i.e. V -> v (h = 0) in DC and AC.
        htr = analysis("tran") ? 1.0 : 0.0;
        // jfet2trun.c truncates qgs and qgd only: the trap and thermal
        // lowpasses and the drain-source cap join no LTE check.
        (* vera_lte = 0 *) I(ntgs) <+ (V(ntgs) - vgs) * 1.0 + htr * ddt(taug * V(ntgs));
        (* vera_lte = 0 *) I(ntgd) <+ (V(ntgd) - vgd) * 1.0 + htr * ddt(taug * V(ntgd));
        vgsf = V(ntgs);
        vgdf = V(ntgd);

        // Source-drain reversal: work with vdse >= 0, flip the channel current.
        if (vds < 0.0) begin
            mode = -1.0;
            vgsa = vgd;  vgda = vgs;
            vgsat = vgdf; vgdat = vgsf;
        end else begin
            mode = 1.0;
            vgsa = vgs;  vgda = vgd;
            vgsat = vgsf; vgdat = vgdf;
        end
        vdse = vgsa - vgda;

        // Rate-dependent threshold: LF feedback on the trapped drain bias plus
        // the HF terms, which vanish when the filters have settled.
        lfgt = lfgam - lfg1 * vgsa + lfg2 * vgda;
        hfgt = hfgam - hfg1 * vgsa + hfg2 * vgda;
        hfet = hfeta - hfe1 * vgsa + hfe2 * vgda;
        vgst = vgsa - vto - lfgt * vgdat
             + hfet * (vgsat - vgsa) + hfgt * (vgdat - vgda);

        // Subthreshold softplus vgt = vst*ln(1+exp(vgst/vst)) with the
        // large-argument continuations ln(1+e^x) -> x for x >> 0 and -> e^x
        // for x << 0. Clamping the argument instead would freeze vgt at
        // 40*vst and kill gm.
        if (vst > 0.0) begin
            vstx = max(vst * (1.0 + mvst * vdse), 1e-12);
            sarg = vgst / vstx;
            if (sarg > 40.0)
                vgt = vgst;
            else if (sarg < -10.0)
                vgt = vstx * exp(sarg);
            else
                vgt = vstx * ln(1.0 + exp(sarg));
        end else begin
            vgt = max(vgst, 0.0);
        end

        // Core PS chain: dual power law + two-sqrt early saturation + Q-law.
        vgte  = max(vgt, 1e-12);
        vdp   = vdse * d3 * pow(vgte, p - q);
        vsatf = vgte / (mxi * vgte + xiwoo);
        vsat  = vgte / (1.0 + vsatf);
        aa    = za * vdp + vsat / 2.0;
        aaa   = aa - vsat;
        argz  = vsat * vsat * z / 4.0;
        vdt   = sqrt(aa * aa + argz) - sqrt(aaa * aaa + argz);
        vgm   = max(vgte - vdt, 0.0);
        idr   = vdt * pow(vgm, q - 1.0)
              + vgte * (pow(vgte, q - 1.0) - pow(vgm, q - 1.0));
        idclm = idr * beta * aeff * (1.0 + lambda * vdse);
        if (vgt <= 0.0) idclm = 0.0;

        // Self-heating: filtered dissipation, then the thermal reduction.
        (* vera_lte = 0 *) I(ntp) <+ (V(ntp) - vdse * idclm) * 1.0 + htr * ddt(taud * V(ntp));
        pbar = V(ntp);
        id   = mode * idclm / (1.0 + pbar * delta / aeff);

        // Statz gate charge (qgg) with the FC forward extension, partitioned
        // between the two junctions by the smoothed vds ratio.
        vert = sqrt(vds * vds + alphac);
        veff = 0.5 * (vgs + vgd + vert) + acgam * vds;
        vnr  = (1.0 - xc) * (veff - vto);
        vnrt = sqrt(vnr * vnr + 0.04);
        vnew = veff + 0.5 * (vnrt - vnr);
        cfac = 0.5 * (1.0 + xc + (1.0 - xc) * vnr / vnrt);
        if (vnew < vmax) begin
            qrt  = sqrt(1.0 - vnew / pb_t);
            qgg  = czgs * 2.0 * pb_t * (1.0 - qrt) + czgd * (veff - vert);
            cgso = cfac / qrt;
        end else begin
            vx   = (vnew - vmax) / 2.0;
            par  = 1.0 + vx / (pb_t - vmax);
            qrt  = sqrt(1.0 - vmax / pb_t);
            ext  = vx * (1.0 + par) / qrt;
            qgg  = czgs * (2.0 * pb_t * (1.0 - qrt) + ext) + czgd * (veff - vert);
            cgso = cfac * par / qrt;
        end
        cpm    = vds / vert;
        cplus  = (1.0 + cpm) / 2.0;
        cminus = (1.0 - cpm) / 2.0;
        ccgs   = cgso * czgs * (cplus + acgam) + czgd * (cminus + acgam);
        ccgd   = cgso * czgs * (cminus - acgam) + czgd * (cplus - acgam);
        ctot   = ccgs + ccgd;
        if (ctot > 0.0) begin
            qgs = qgg * ccgs / ctot;
            qgd = qgg * ccgd / ctot;
        end else begin
            qgs = 0.0;
            qgd = 0.0;
        end

        // Stamps: the two gate junctions with their charges, then the channel.
        // jtype on every terminal contribution (JFET2type in the reference).
        I(g, si) <+ jtype * gjunc(vgs, isat, nvt, ibrk, vbd, m * gmin) + ddt(jtype * qgs);
        I(g, di) <+ jtype * gjunc(vgd, isat, nvt, ibrk, vbd, m * gmin) + ddt(jtype * qgd);
        I(di, si) <+ jtype * id + ddt (* vera_lte = 0 *) (cds * aeff * V(di, si));

        // ---- noise (jfet2noi.c): RD/RS thermal, channel thermal 2/3|gm|,
        // flicker KF|Id|^AF/f. Raising V(g) raises vgs and vgd together, so
        // ddx(id, V(g)) is dId/dVgs at constant Vds, the reference's gm.
        gm = abs(ddx(id, V(g)));
        I(di, si) <+ white_noise(fourkt * (2.0 / 3.0) * gm * m, "channel");
        if (kf > 0.0)
            I(di, si) <+ flicker_noise(m * kf * pow(abs(id), af), 1.0, "flicker");

        // Series RD/RS: zero is an exact short.
        if (rd > 0.0) begin
            I(brd) <+ grd * V(brd);
            I(brd) <+ white_noise(fourkt * grd, "rd");
        end else V(brd) <+ 0.0;
        if (rs > 0.0) begin
            I(brs) <+ grs * V(brs);
            I(brs) <+ white_noise(fourkt * grs, "rs");
        end else V(brs) <+ 0.0;
    end
endmodule
