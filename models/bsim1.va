// BSIM1: Berkeley Short-Channel IGFET Model 1 (ngspice netlist letter M, level 4).
//
// Verilog-A implementation: Omar El-Sawy, University of Waterloo.
// Based on: ngspice bsim1 (b1temp.c, b1eval.c, b1ld.c, b1set.c), BSIM1 by the
//   UC Berkeley BSIM group (B. J. Sheu, D. L. Scharfetter, P. K. Ko, M.-C. Jeng).
//   ngspice: Copyright Regents of the University of California and others,
//   modified BSD license.
//
// Laid out like models/mos1.va (same sections, same local names); the channel
// core is b1eval.c's. Channel between d' and s', bulk diodes b-d'/b-s',
// charge-based intrinsic caps (no Meyer).
//
// Deliberate divergences from ngspice:
//   * Junction currents/charges carry `type` and use the true node voltages,
//     and the intrinsic drain charge is un-swapped for V(di,si) < 0 (b1ld.c
//     ceqbs/ceqbd/ceqqg and the B1mosCap argument+output swap).
//
// `temp` is ngspice's model TEMP in degC (b1.c:97), stored and never read
// (b1set.c:190-192): Vt is CONSTvt0 at 300.15 K whatever the circuit
// temperature (b1ld.c:361-380), and the thermal noise is at the circuit
// temperature (b1noi.c:81-91, nevalsrc.c:110-111).

`include "constants.vams"
`include "disciplines.vams"

module bsim1(d, g, s, b);
    inout d, g, s, b;
    electrical d, g, s, b;
    electrical di, si;              // internal drain/source behind rd/rs

    // ---- threshold ---------------------------------------------------------
    parameter real vfb  = 0.0;   parameter real lvfb = 0.0;   parameter real wvfb = 0.0;
    parameter real phi  = 0.0;   parameter real lphi = 0.0;   parameter real wphi = 0.0;
    parameter real k1   = 0.0;   parameter real lk1  = 0.0;   parameter real wk1  = 0.0;
    parameter real k2   = 0.0;   parameter real lk2  = 0.0;   parameter real wk2  = 0.0;

    // ---- DIBL --------------------------------------------------------------
    parameter real eta  = 0.0;   parameter real leta = 0.0;   parameter real weta = 0.0;
    parameter real x2e  = 0.0;   parameter real lx2e = 0.0;   parameter real wx2e = 0.0;
    parameter real x3e  = 0.0;   parameter real lx3e = 0.0;   parameter real wx3e = 0.0;

    // ---- mobility ----------------------------------------------------------
    parameter real muz  = 0.0;
    parameter real x2mz = 0.0;   parameter real lx2mz = 0.0;  parameter real wx2mz = 0.0;
    parameter real mus  = 0.0;   parameter real lmus  = 0.0;  parameter real wmus  = 0.0;
    parameter real x2ms = 0.0;   parameter real lx2ms = 0.0;  parameter real wx2ms = 0.0;
    parameter real x3ms = 0.0;   parameter real lx3ms = 0.0;  parameter real wx3ms = 0.0;
    parameter real u0   = 0.0;   parameter real lu0   = 0.0;  parameter real wu0   = 0.0;
    parameter real x2u0 = 0.0;   parameter real lx2u0 = 0.0;  parameter real wx2u0 = 0.0;
    parameter real u1   = 0.0;   parameter real lu1   = 0.0;  parameter real wu1   = 0.0;
    parameter real x2u1 = 0.0;   parameter real lx2u1 = 0.0;  parameter real wx2u1 = 0.0;
    parameter real x3u1 = 0.0;   parameter real lx3u1 = 0.0;  parameter real wx3u1 = 0.0;

    // ---- subthreshold slope ------------------------------------------------
    parameter real n0 = 0.0;     parameter real ln0 = 0.0;    parameter real wn0 = 0.0;
    parameter real nb = 0.0;     parameter real lnb = 0.0;    parameter real wnb = 0.0;
    parameter real nd = 0.0;     parameter real lnd = 0.0;    parameter real wnd = 0.0;

    // ---- process -----------------------------------------------------------
    parameter real tox = 0.0 from [0:inf);   // um
    parameter real dl  = 0.0;                // um
    parameter real dw  = 0.0;                // um
    parameter real ld  = 0.0;                // m, lateral diffusion (geometry bookkeeping)
    parameter real vdd = 0.0;                // V, reference bias for MUS

    // ---- series resistance, bulk junctions --------------------------------
    parameter real rsh  = 0.0 from [0:inf);
    parameter real nrd  = 1.0 from [0:inf);   // squares of drain diffusion
    parameter real nrs  = 1.0 from [0:inf);   // squares of source diffusion
    parameter real js   = 0.0;
    parameter real pb   = 0.1;
    parameter real mj   = 0.0;
    parameter real pbsw = 0.1;
    parameter real mjsw = 0.0;
    parameter real cj   = 0.0;
    parameter real cjsw = 0.0;
    parameter real wdf  = 0.0;   // um
    parameter real dell = 0.0;   // um

    // ---- gate overlap capacitance ------------------------------------------
    parameter real cgso = 0.0;
    parameter real cgdo = 0.0;
    parameter real cgbo = 0.0;

    // ---- noise -------------------------------------------------------------
    parameter real kf = 0.0;
    parameter real af = 1.0;

    // ---- charge partition, polarity, instance -----------------------------
    parameter integer xpart = 0 from [0:1];             // 0 = 40/60, 1 = 0/100
    parameter integer type  = 1 from [-1:1] exclude 0;  // 1 = NMOS, -1 = PMOS
    parameter real w    = 5e-6   from (0:inf);
    parameter real l    = 5e-6   from (0:inf);
    parameter real temp = 27.0;                         // degC, never read
    parameter real m    = 1.0    from (0:inf);
    // Junction geometry (b1.c:15-18), 0 when not given (b1set.c:284-310):
    // no area means the 1e-15 A saturation floor and no junction caps
    // (b1ld.c:139-149, 439-442).
    parameter real ad   = 0.0    from [0:inf);          // m^2 drain area
    parameter real as   = 0.0    from [0:inf);          // m^2 source area
    parameter real pd   = 0.0    from [0:inf);          // m   drain perimeter
    parameter real ps   = 0.0    from [0:inf);          // m   source perimeter

    // bias-independent
    real leff, weffr, lum, wum, wm, toxcm, cox, coxp, bfac, wlcox;
    real vfbe, phie, k1e, k2e, etae, x2ee, x3ee;
    real x2mze, muse, x2mse, x3mse, u0e, x2u0e, u1e, x2u1e, x3u1e;
    real n0e, nbe, nde;
    real bz0, bzb, bvd, bvdb, bvdd_d, bvds0, bvdd;
    real vt, adrain, asource, pdrain, psource, isatd, isats, vcrits, vcritd;
    real pbc, pbswc, czbs, czbssw, czbd, czbdsw;
    real gdrain, gsource;
    // bias-dependent
    real ty, vtx;
    real vgs, vgd, vds, vbs, vbd, vbst, ibs, ibd;
    real mode, vdsneg, vgsx, vdsx, vbx;
    real ugse, udsr, udss, etac, vpb, sqvpb, von, vgst;
    real gfac, afac, arg, beta0, beta, c1, c2, vc, kfac, vdsat;
    real vdse, argl1, argl2, idmain, nsub, wds, wgs, iw0, ilim, isub, id;
    real gmnoi, gmsub;
    real vth0, vgst0, qgsat, qbsat, qdsat, qbs, qbd, qdi;

    // Bulk junction current. The exponent is tangent-continued above 80*vtx
    // so the restoring slope survives evaluations at unlimited v.
    analog function real jcur;
        input v, isat, vtx, gm;
        real v, isat, vtx, gm;
        real u;
        begin
            u = min(v / vtx, 80.0);
            jcur = isat * (exp(u) * (1.0 + (v / vtx - u)) - 1.0) + gm * v;
        end
    endfunction

    analog begin
        // ============ parameter defaulting (b1temp.c) =====================
        leff  = max(l - dl * 1e-6, 1e-9);
        weffr = max(w, 1e-9);
        lum   = max(leff * 1e6, 0.01);
        wum   = max(weffr * 1e6 - dw, 0.01);
        wm    = max(weffr - dw * 1e-6, 1e-8);

        toxcm = tox > 0.0 ? tox * 1e-4 : 1e-5;
        cox   = 3.453e-13 / toxcm;              // F/cm^2
        coxp  = cox * 1e4;                      // F/m^2, for the flicker PSD

        // P_eff = P0 + LP/Leff_um + WP/Weff_um
        vfbe  = vfb  + lvfb  / lum + wvfb  / wum;
        phie  = max(phi + lphi / lum + wphi / wum, 0.1);
        // b1temp.c:124-125 clamps both body-effect coefficients at 0.
        k1e   = max(k1 + lk1 / lum + wk1 / wum, 0.0);
        k2e   = max(k2 + lk2 / lum + wk2 / wum, 0.0);
        etae  = eta  + leta  / lum + weta  / wum;
        x2ee  = x2e  + lx2e  / lum + wx2e  / wum;
        x3ee  = x3e  + lx3e  / lum + wx3e  / wum;
        x2mze = x2mz + lx2mz / lum + wx2mz / wum;
        muse  = mus  + lmus  / lum + wmus  / wum;
        x2mse = x2ms + lx2ms / lum + wx2ms / wum;
        x3mse = x3ms + lx3ms / lum + wx3ms / wum;
        u0e   = u0   + lu0   / lum + wu0   / wum;
        x2u0e = x2u0 + lx2u0 / lum + wx2u0 / wum;
        u1e   = u1   + lu1   / lum + wu1   / wum;
        x2u1e = x2u1 + lx2u1 / lum + wx2u1 / wum;
        x3u1e = x3u1 + lx3u1 / lum + wx3u1 / wum;
        n0e   = n0   + ln0   / lum + wn0   / wum;
        nbe   = nb   + lnb   / lum + wnb   / wum;
        nde   = nd   + lnd   / lum + wnd   / wum;

        // CoxWoverL = Cox[F/cm^2] * Weff/Leff [um/um] — b1temp.c:81 has no
        // further unit factor (mobility is cm^2/Vs, so muz*bfac is A/V^2),
        // and only the five beta interpolation params are scaled by it
        // (b1temp.c:134-138). The U0/U1 families stay raw 1/V (b1eval.c:159-173).
        bfac   = cox * (wum / lum);
        bz0    = muz   * bfac;      // beta at Vds=0, Vbs=0
        bzb    = x2mze * bfac;
        bvd    = muse  * bfac;      // beta at Vds=Vdd
        bvdb   = x2mse * bfac;
        // b1temp.c:138 MAXes the scaled dBeta/dVds at zero (b1eval.c:219 MAXes
        // it a second time): a negative X3MS must not tilt Beta0 downward.
        bvdd_d = max(x3mse * bfac, 0.0);

        // ============ temperature scaling =================================
        // BSIM1 has no temperature model: Vt is CONSTvt0 at REFTEMP 300.15 K.
        vt = 1.38064852e-23 * 300.15 / 1.6021766208e-19;

        // ============ geometry, junction sizing ===========================
        asource = as;
        adrain  = ad;
        psource = ps;
        pdrain  = pd;
        isats   = max(asource * js, 1e-15);
        isatd   = max(adrain  * js, 1e-15);
        vcrits  = vt * ln(vt / (1.4142135623730951 * isats));
        vcritd  = vt * ln(vt / (1.4142135623730951 * isatd));

        // b1temp.c clamps both potentials at 0.1 (a 0.01 floor blows up the
        // czb*mj/pbc charge coefficients).
        pbc    = max(pb,   0.1);
        pbswc  = max(pbsw, 0.1);
        czbs   = cj   * asource;
        czbssw = cjsw * psource;
        czbd   = cj   * adrain;
        czbdsw = cjsw * pdrain;

        wlcox = cox * leff * wm * 1e4;

        // ============ series resistance ===================================
        // G = 1/(RSH*NR), per side; zero collapses d'->d.
        gdrain  = (rsh > 0.0 && nrd > 0.0) ? m / (rsh * nrd) : 0.0;
        gsource = (rsh > 0.0 && nrs > 0.0) ? m / (rsh * nrs) : 0.0;

        // ============ bias and limiting (b1ld.c) ==========================
        // mos1.va's ladder, which b1ld.c shares: "fetlimds" on both gate legs +
        // "limvds" fetlims the leg the OLD vds picks and derives the other;
        // "pnjlimds" limits one bulk junction, picked by the LIMITED vds, and
        // moves only the bulk with V_crit = Vt*ln(Vt/(sqrt(2)*Is)). The trailing `ty`
        // is VerA's frame sign; it must be real-typed, hence the copy.
        ty  = type;
        vtx = vfbe + phie + k1e * sqrt(phie) - k2e * phie;  // zero-bias von
        // The argument after the frame sign is the MODEINITJCT seed: vgs =
        // type*vt0, vds = 0, vbs = -1. ponytail: fetlim's threshold is the
        // zero-bias von, where b1ld.c uses the previous load's von; porting the
        // von chain ahead of the limits (as mos1.va does) is the upgrade.
        vgs = ty * $limit(V(g, si), "fetlimds", vtx, ty, ty * vtx);
        vgd = ty * $limit(V(g, di), "fetlimds", vtx, ty);
        vds = ty * $limit(V(di, si), "limvds", ty, 0.0);
        vbst = V(b,  si) * type;
        vbs = ty * $limit(V(b, si), "pnjlimds", vt, vcrits, ty, -1.0);
        vbd = ty * $limit(V(b, di), "pnjlimds", vt, vcritd, ty);

        // ============ bulk junctions ======================================
        // Mode-free, on the true junction voltages: the swapped vbx below is
        // for the channel only; using it here would put the source diode on
        // d' when V(di,si) < 0.
        ibs = jcur(vbs, isats, vt, 1e-12);
        ibd = jcur(vbd, isatd, vt, 1e-12);

        // ============ mode swap ===========================================
        // Vds is made positive, the gate and bulk references move to the true
        // source, and `mode` carries the sign back to the channel stamp.
        vdsx   = abs(vds);
        vdsneg = min(vds, 0.0);
        mode   = vds >= 0.0 ? 1.0 : -1.0;
        vgsx   = vgs - vdsneg;
        vbx    = vbst - vdsneg;

        // ============ drain current (b1eval.c) ============================
        // bias-dependent mobility / DIBL coefficients
        ugse = max(u0e + x2u0e * vbx, 0.0);
        udsr = u1e + x2u1e * vbx + x3u1e * (vdsx - vdd);
        udss = max(udsr, 0.0) / lum;
        etac = min(max(etae + x2ee * vbx + x3ee * (vdsx - vdd), 0.0), 1.0);

        // threshold
        vpb   = phie - min(vbx, 0.0);
        sqvpb = sqrt(max(vpb, 0.001));
        von   = vfbe + phie + k1e * sqvpb - k2e * vpb - etac * vdsx;
        vgst  = vgsx - von;

        // bulk-charge factor
        gfac = 1.0 - 1.0 / (1.744 + 0.8364 * vpb);
        afac = max(1.0 + gfac * k1e / (2.0 * sqvpb), 1.0);
        arg  = max(1.0 + ugse * vgst, 1.0);

        // Beta vs Vds, b1eval.c:217-235: quadratic interpolation between the
        // Vds=0 endpoint (MUZ) and the Vds=VDD endpoint (MUS) below VDD, linear
        // extrapolation off the MUS endpoint above it. The branch is on
        // `vdsx > Vdd`: with the default VDD = 0 (b1set.c:194) every vdsx > 0
        // extrapolates, so a card that also leaves MUS = 0 (b1set.c:80) has no
        // strong-inversion current and only the subthreshold term remains.
        // At vdd == 0 b1eval.c's else-branch divides by zero (Beta0 = NaN,
        // MAX(NaN,0) = 0); vdsx is 0 there too, so the Vds=0 endpoint gives the
        // same current without the NaN.
        bvds0 = bz0 + bzb  * vbx;                // Beta_Vds_0
        bvdd  = bvd + bvdb * vbx;                // BetaVdd
        if (vdsx > vdd) begin
            beta0 = bvdd + bvdd_d * (vdsx - vdd);
        end else if (vdd > 0.0) begin
            c1    = (-bvdd + bvds0 + bvdd_d * vdd) / (vdd * vdd);
            c2    = 2.0 * (bvdd - bvds0) / vdd - bvdd_d;
            beta0 = (c1 * vdsx + c2) * vdsx + bvds0;
        end else begin
            beta0 = bvds0;
        end
        beta = beta0 / arg;

        // saturation voltage
        vc    = max(udss * vgst / afac, 0.0);
        kfac  = 0.5 * (1.0 + vc + sqrt(1.0 + 2.0 * vc));
        vdsat = max(vgst / (afac * sqrt(kfac)), 0.0);

        // Strong-inversion current. b1eval.c has NO channel-length modulation:
        // above Vdsat the current is flat at 0.5*Beta*Vgs_Vth^2/(A*K)
        // (b1eval.c:276-278), and the triode expression evaluated at vdsx = Vdsat
        // IS that value -- with s = sqrt(K) = (1 + sqrt(1+2*Vc))/2 one has
        // s + Vc = s*(2s-1), so triode(Vdsat)/sat = (2s-1)/(1 + Vc/s) = 1.
        vdse   = min(vdsx, vdsat);
        argl1  = max(1.0 + udss * vdse, 1.0);
        argl2  = max(vgst, 0.0) - 0.5 * afac * vdse;
        idmain = beta * argl2 * vdse / argl1;

        // subthreshold, parallel-limited to 4.5*Vt^2*beta0(0,0)
        isub  = 0.0;
        gmsub = 0.0;
        if (n0e < 200.0 && bz0 > 0.0) begin
            nsub = max(n0e + nbe * vbx + nde * vdsx, 0.5);
            wds  = 1.0 - exp(-min(max(vdsx / vt, 0.0), 80.0));
            wgs  = exp(min(vgst / (nsub * vt), 80.0));
            iw0  = 6.04965 * vt * vt * bz0 * wgs * wds;
            ilim = 4.5 * vt * vt * bz0;
            isub = ilim * iw0 / (ilim + iw0);
            gmsub = (ilim / (ilim + iw0)) * (ilim / (ilim + iw0))
                    * iw0 / (nsub * vt);
        end

        id = max(idmain + isub, 0.0);

        // gm for the noise PSDs only (AD owns the Jacobian).
        // ponytail: dId/dVgs of the triode core without the beta(vgst) and
        // Vdsat(vgst) terms; refine if noise fixtures care.
        gmnoi = (vgst > 0.0 ? beta * vdse / argl1 : 0.0) + gmsub;

        // ============ junction and gate charges ===========================
        // Intrinsic 40/60 (or 0/100) saturation charges, in the swapped frame
        // like the channel current.
        vth0  = vfbe + phie + k1e * sqvpb;          // threshold without DIBL
        vgst0 = vgsx - vth0;
        qgsat = wlcox * (vgsx - vfbe - phie - vgst0 / (3.0 * afac));
        qbsat = wlcox * (vfbe + phie - vth0 + (1.0 - afac) * vgst0 / (3.0 * afac));
        qdsat = (xpart != 0) ? 0.0 : -(4.0 / 15.0) * wlcox * vgst0;

        // Un-swap: the intrinsic drain charge belongs to the true drain, so with
        // V(di,si) < 0 node d' carries the swapped-source charge instead
        // (= -(Qg+Qb+Qd), b1ld.c's B1mosCap output swap).
        // ponytail: saturation partition only, so this exchange steps at
        // Vds=0; add B1mosCap's triode partition if a transient fixture needs it.
        qdi = (mode > 0.0) ? qdsat : -(qgsat + qbsat + qdsat);

        // Junction depletion charges, on the true (typed) junction voltages.
        qbs = vbs * (czbs + czbssw) +
              0.5 * vbs * vbs * (czbs * mj / pbc + czbssw * mjsw / pbswc);
        qbd = vbd * (czbd + czbdsw) +
              0.5 * vbd * vbd * (czbd * mj / pbc + czbdsw * mjsw / pbswc);

        // ============ contributions =======================================
        // Channel (sign follows the swap) and bulk diodes (type-folded).
        I(di, si) <+ mode * type * m * id;
        I(b, di)  <+ m * type * ibd;
        I(b, si)  <+ m * type * ibs;
        // Junction + intrinsic charges: type-folded on the way out (b1ld.c
        // ceqqg/ceqqb/ceqqd), referenced to s' so q(s') = -(qg+qb+qd') holds.
        I(b, di)  <+ m * type * ddt(qbd);
        I(b, si)  <+ m * type * ddt(qbsat + qbs);
        // Overlap charges on the true node voltages, where the two type
        // factors cancel, so they are both mode- and PMOS-safe.
        I(g, si)  <+ m * ddt(cgso * wm   * V(g, si));
        I(g, di)  <+ m * ddt(cgdo * wm   * V(g, di));
        I(g, b)   <+ m * ddt(cgbo * leff * V(g, b));
        I(g, si)  <+ m * type * ddt(qgsat);
        I(di, si) <+ m * type * ddt(qdi);

        // Series resistances with their thermal noise, or node collapse when
        // RSH*NR is zero.
        if (gdrain > 0.0) begin
            I(d, di) <+ gdrain * V(d, di)
                      + white_noise(4.0 * 1.38064852e-23 * $temperature * gdrain, "rd");
        end else begin
            V(d, di) <+ 0.0;
        end
        if (gsource > 0.0) begin
            I(s, si) <+ gsource * V(s, si)
                      + white_noise(4.0 * 1.38064852e-23 * $temperature * gsource, "rs");
        end else begin
            V(s, si) <+ 0.0;
        end

        // ============ noise (mos1noi.c form) ==============================
        // Cox'^2 in the flicker denominator.
        I(di, si) <+ white_noise(4.0 * 1.38064852e-23 * $temperature * (2.0 / 3.0) * abs(gmnoi),
                                 "channel");
        if (kf > 0.0) begin
            I(di, si) <+ flicker_noise(kf * pow(abs(id), af)
                                       / (wm * m * leff * coxp * coxp), 1.0, "flicker");
        end
    end
endmodule
