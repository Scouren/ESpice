* SpiceRack twin: the deck fake_spice2rack.sh writes as its translation of deck.hsp, run natively as the oracle
v1 in 0 pulse(0 1 0 1n 1n 1u 2u)
r1 in out 1k
c1 out 0 1n
.tran 10n 3u
.end
